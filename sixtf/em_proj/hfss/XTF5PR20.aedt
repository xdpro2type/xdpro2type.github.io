# Ansys Electronics Desktop project, version 2018.1
materials:
  vacuum: permittivity=1
  ihp_SI: permittivity=11.9 permeability=1 conductivity=2 lande_g_factor=2
  ihp_EPI: permittivity=11.9 permeability=1 conductivity=3.75 lande_g_factor=2
  ihp_SIO2: permittivity=4.1 permeability=1 lande_g_factor=2
  ihp_MIMD: permittivity=6.75 permeability=1 lande_g_factor=2
  ihp_PSV: permittivity=6.6 permeability=1 lande_g_factor=2
  ihp_air: permittivity=1 permeability=1 lande_g_factor=2
  TopMetal2: permittivity=1 permeability=1 conductivity=30300000 lande_g_factor=2
  TopMetal1: permittivity=1 permeability=1 conductivity=27800000 lande_g_factor=2
  MIM: permittivity=1 permeability=1 conductivity=500000 lande_g_factor=2
  Metal5: permittivity=1 permeability=1 conductivity=23190000 lande_g_factor=2
  Metal4: permittivity=1 permeability=1 conductivity=23190000 lande_g_factor=2
  Metal3: permittivity=1 permeability=1 conductivity=23190000 lande_g_factor=2
  Metal2: permittivity=1 permeability=1 conductivity=23190000 lande_g_factor=2
  Metal1: permittivity=1 permeability=1 conductivity=23190000 lande_g_factor=2
  Activ: permittivity=1 permeability=1 conductivity=357000000000 lande_g_factor=2
  TopVia2: permittivity=1 permeability=1 conductivity=3143000 lande_g_factor=2
  TopVia1: permittivity=1 permeability=1 conductivity=2191000 lande_g_factor=2
  Vmim: permittivity=1 permeability=1 conductivity=2191000 lande_g_factor=2
  Via1: permittivity=1 permeability=1 conductivity=1160000 lande_g_factor=2
  Via2: permittivity=1 permeability=1 conductivity=1160000 lande_g_factor=2
  Via3: permittivity=1 permeability=1 conductivity=1160000 lande_g_factor=2
  Via4: permittivity=1 permeability=1 conductivity=1160000 lande_g_factor=2
  air: permittivity=1.0006 permeability=1.0000004
  default_via_material: permeability=0.999991 conductivity=58000000
  default_via_material0: permeability=0.999991 conductivity=58000000
  default_via_material1: permeability=0.999991 conductivity=58000000
  default_via_material2: permeability=0.999991 conductivity=58000000
  default_via_material3: permeability=0.999991 conductivity=58000000
  default_via_material4: permeability=0.999991 conductivity=58000000
  default_via_material5: permeability=0.999991 conductivity=58000000
  default_via_material6: permeability=0.999991 conductivity=58000000
  default_via_material7: permeability=0.999991 conductivity=58000000
  default_via_material8: permeability=0.999991 conductivity=58000000
  default_via_material9: permeability=0.999991 conductivity=58000000
  default_via_material10: permeability=0.999991 conductivity=58000000
  default_via_material11: permeability=0.999991 conductivity=58000000
  default_via_material12: permeability=0.999991 conductivity=58000000
  default_via_material13: permeability=0.999991 conductivity=58000000
  default_via_material14: permeability=0.999991 conductivity=58000000
  default_via_material15: permeability=0.999991 conductivity=58000000
  default_via_material16: permeability=0.999991 conductivity=58000000
  default_via_material17: permeability=0.999991 conductivity=58000000
  default_via_material18: permeability=0.999991 conductivity=58000000
  default_via_material19: permeability=0.999991 conductivity=58000000
  default_via_material20: permeability=0.999991 conductivity=58000000
  default_via_material21: permeability=0.999991 conductivity=58000000
  default_via_material22: permeability=0.999991 conductivity=58000000
  default_via_material23: permeability=0.999991 conductivity=58000000
  default_via_material24: permeability=0.999991 conductivity=58000000
  default_via_material25: permeability=0.999991 conductivity=58000000
  default_via_material26: permeability=0.999991 conductivity=58000000
  default_via_material27: permeability=0.999991 conductivity=58000000
  default_via_material28: permeability=0.999991 conductivity=58000000
  default_via_material29: permeability=0.999991 conductivity=58000000
  default_via_material30: permeability=0.999991 conductivity=58000000
  default_via_material31: permeability=0.999991 conductivity=58000000
  default_via_material32: permeability=0.999991 conductivity=58000000
  default_via_material33: permeability=0.999991 conductivity=58000000
  default_via_material34: permeability=0.999991 conductivity=58000000
  default_via_material35: permeability=0.999991 conductivity=58000000
  default_via_material36: permeability=0.999991 conductivity=58000000
  default_via_material37: permeability=0.999991 conductivity=58000000
  default_via_material38: permeability=0.999991 conductivity=58000000
  default_via_material39: permeability=0.999991 conductivity=58000000
  default_via_material40: permeability=0.999991 conductivity=58000000
  default_via_material41: permeability=0.999991 conductivity=58000000
  default_via_material42: permeability=0.999991 conductivity=58000000
  default_via_material43: permeability=0.999991 conductivity=58000000
  default_via_material44: permeability=0.999991 conductivity=58000000
  default_via_material45: permeability=0.999991 conductivity=58000000
  default_via_material46: permeability=0.999991 conductivity=58000000
  default_via_material47: permeability=0.999991 conductivity=58000000
  default_via_material48: permeability=0.999991 conductivity=58000000
  default_via_material49: permeability=0.999991 conductivity=58000000
  default_via_material50: permeability=0.999991 conductivity=58000000
  default_via_material51: permeability=0.999991 conductivity=58000000
  default_via_material52: permeability=0.999991 conductivity=58000000
  default_via_material53: permeability=0.999991 conductivity=58000000
  default_via_material54: permeability=0.999991 conductivity=58000000
  default_via_material55: permeability=0.999991 conductivity=58000000
  default_via_material56: permeability=0.999991 conductivity=58000000
  default_via_material57: permeability=0.999991 conductivity=58000000
  default_via_material58: permeability=0.999991 conductivity=58000000
  default_via_material59: permeability=0.999991 conductivity=58000000
  default_via_material60: permeability=0.999991 conductivity=58000000
  default_via_material61: permeability=0.999991 conductivity=58000000
  default_via_material62: permeability=0.999991 conductivity=58000000
  default_via_material63: permeability=0.999991 conductivity=58000000
  default_via_material64: permeability=0.999991 conductivity=58000000
  default_via_material65: permeability=0.999991 conductivity=58000000
  default_via_material66: permeability=0.999991 conductivity=58000000
  default_via_material67: permeability=0.999991 conductivity=58000000
  default_via_material68: permeability=0.999991 conductivity=58000000
  default_via_material69: permeability=0.999991 conductivity=58000000
  default_via_material70: permeability=0.999991 conductivity=58000000
  default_via_material71: permeability=0.999991 conductivity=58000000
  default_via_material72: permeability=0.999991 conductivity=58000000
  default_via_material73: permeability=0.999991 conductivity=58000000
  default_via_material74: permeability=0.999991 conductivity=58000000
  default_via_material75: permeability=0.999991 conductivity=58000000
  default_via_material76: permeability=0.999991 conductivity=58000000
  default_via_material77: permeability=0.999991 conductivity=58000000
  default_via_material78: permeability=0.999991 conductivity=58000000
  default_via_material79: permeability=0.999991 conductivity=58000000
  default_via_material80: permeability=0.999991 conductivity=58000000
  default_via_material81: permeability=0.999991 conductivity=58000000
  default_via_material82: permeability=0.999991 conductivity=58000000
  default_via_material83: permeability=0.999991 conductivity=58000000
  default_via_material84: permeability=0.999991 conductivity=58000000
  default_via_material85: permeability=0.999991 conductivity=58000000
  default_via_material86: permeability=0.999991 conductivity=58000000
  default_via_material87: permeability=0.999991 conductivity=58000000
  default_via_material88: permeability=0.999991 conductivity=58000000
  default_via_material89: permeability=0.999991 conductivity=58000000
  default_via_material90: permeability=0.999991 conductivity=58000000
  default_via_material91: permeability=0.999991 conductivity=58000000
  default_via_material92: permeability=0.999991 conductivity=58000000
  default_via_material93: permeability=0.999991 conductivity=58000000
  default_via_material94: permeability=0.999991 conductivity=58000000
  default_via_material95: permeability=0.999991 conductivity=58000000
  default_via_material96: permeability=0.999991 conductivity=58000000
  default_via_material97: permeability=0.999991 conductivity=58000000
  default_via_material98: permeability=0.999991 conductivity=58000000
  default_via_material99: permeability=0.999991 conductivity=58000000
  default_via_material100: permeability=0.999991 conductivity=58000000

design XTF5PR20 (HFSS, DrivenModal, model units mm)
options: Allow_Material_Override
variables:
  extent_x_pos = 1000mm
  extent_y_pos = 1000mm
  extent_x_size = -1000mm
  extent_y_size = -1000mm
  Activ_thickness = 0.0004mm
  Activ_lower_elevation = 0.28375mm
  extent_x_pos_1 = 1000mm
  extent_y_pos_1 = 1000mm
  extent_x_size_1 = -1000mm
  extent_y_size_1 = -1000mm
  Metal1_thickness = 0.00049mm
  Metal1_lower_elevation = 0.28479mm
  extent_x_pos_2 = 1000mm
  extent_y_pos_2 = 1000mm
  extent_x_size_2 = -1000mm
  extent_y_size_2 = -1000mm
  Metal2_thickness = 0.00049mm
  Metal2_lower_elevation = 0.28575mm
  extent_x_pos_3 = 1000mm
  extent_y_pos_3 = 1000mm
  extent_x_size_3 = -1000mm
  extent_y_size_3 = -1000mm
  Metal3_thickness = 0.00049mm
  Metal3_lower_elevation = 0.28678mm
  extent_x_pos_4 = -0.08mm
  extent_y_pos_4 = -0.04mm
  extent_x_size_4 = 0.16mm
  extent_y_size_4 = 0.08mm
  Metal4_thickness = 0.00049mm
  Metal4_lower_elevation = 0.28781mm
  extent_x_pos_5 = -0.08mm
  extent_y_pos_5 = -0.04mm
  extent_x_size_5 = 0.16mm
  extent_y_size_5 = 0.08mm
  Metal5_thickness = 0.00049mm
  Metal5_lower_elevation = 0.28884mm
  extent_x_pos_6 = -0.022mm
  extent_y_pos_6 = -0.04mm
  extent_x_size_6 = 0.044mm
  extent_y_size_6 = 0.062mm
  TopMetal2_thickness = 0.003mm
  TopMetal2_lower_elevation = 0.29552mm
  extent_x_pos_7 = -0.022mm
  extent_y_pos_7 = -0.032mm
  extent_x_size_7 = 0.044mm
  extent_y_size_7 = 0.072mm
  TopMetal1_thickness = 0.002mm
  TopMetal1_lower_elevation = 0.29072mm
  extent_x_pos_8 = 1000mm
  extent_y_pos_8 = 1000mm
  extent_x_size_8 = -1000mm
  extent_y_size_8 = -1000mm
  TopVia2_thickness = 0.0028mm
  TopVia2_lower_elevation = 0.29272mm
  extent_x_pos_9 = 1000mm
  extent_y_pos_9 = 1000mm
  extent_x_size_9 = -1000mm
  extent_y_size_9 = -1000mm
  TopVia1_thickness = 0.00139mm
  TopVia1_lower_elevation = 0.28933mm
  extent_x_pos_10 = 1000mm
  extent_y_pos_10 = 1000mm
  extent_x_size_10 = -1000mm
  extent_y_size_10 = -1000mm
  Vmim_thickness = 0.00066mm
  Vmim_lower_elevation = 0.29006mm
  extent_x_pos_11 = 1000mm
  extent_y_pos_11 = 1000mm
  extent_x_size_11 = -1000mm
  extent_y_size_11 = -1000mm
  MIM_thickness = 0.00066mm
  MIM_lower_elevation = 0.28987mm
  extent_x_pos_12 = 1000mm
  extent_y_pos_12 = 1000mm
  extent_x_size_12 = -1000mm
  extent_y_size_12 = -1000mm
  Via4_thickness = 0.00054mm
  Via4_lower_elevation = 0.2883mm
  extent_x_pos_13 = 1000mm
  extent_y_pos_13 = 1000mm
  extent_x_size_13 = -1000mm
  extent_y_size_13 = -1000mm
  Via3_thickness = 0.00054mm
  Via3_lower_elevation = 0.28727mm
  extent_x_pos_14 = 1000mm
  extent_y_pos_14 = 1000mm
  extent_x_size_14 = -1000mm
  extent_y_size_14 = -1000mm
  Via2_thickness = 0.00054mm
  Via2_lower_elevation = 0.28624mm
  extent_x_pos_15 = 1000mm
  extent_y_pos_15 = 1000mm
  extent_x_size_15 = -1000mm
  extent_y_size_15 = -1000mm
  Via1_thickness = 0.00047mm
  Via1_lower_elevation = 0.28528mm
  extent_x_pos_16 = 1000mm
  extent_y_pos_16 = 1000mm
  extent_x_size_16 = -1000mm
  extent_y_size_16 = -1000mm
  Cont_thickness = 0.00064mm
  Cont_lower_elevation = 0.28415mm
geometry:
  Substrate [ihp_SI] = box(corner=(-100um, -100um, 0um), size=(200um, 200um, 280um))
  EPI [ihp_EPI] = box(corner=(-100um, -100um, 280um), size=(200um, 200um, 3.75um))
  SBM1 [ihp_SIO2] = box(corner=(-100um, -100um, 283.75um), size=(200um, 200um, 1.04um))
  SAM1 [ihp_SIO2] = box(corner=(-100um, -100um, 284.79um), size=(200um, 200um, 0.96um))
  SAM2 [ihp_SIO2] = box(corner=(-100um, -100um, 285.75um), size=(200um, 200um, 1.03um))
  SAM3 [ihp_SIO2] = box(corner=(-100um, -100um, 286.78um), size=(200um, 200um, 1.03um))
  SAM4 [ihp_SIO2] = box(corner=(-100um, -100um, 287.81um), size=(200um, 200um, 1.03um))
  SAM5 [ihp_SIO2] = box(corner=(-100um, -100um, 288.84um), size=(200um, 200um, 0.49um))
  SMIM1 [ihp_MIMD] = box(corner=(-100um, -100um, 289.33um), size=(200um, 200um, 0.04um))
  SMIM2 [ihp_SIO2] = box(corner=(-100um, -100um, 289.37um), size=(200um, 200um, 0.81um))
  TM1 [ihp_SIO2] = box(corner=(-100um, -100um, 290.18um), size=(200um, 200um, 4.8um))
  TM2 [ihp_SIO2] = box(corner=(-100um, -100um, 294.98um), size=(200um, 200um, 4.5um))
  PSV [ihp_PSV] = box(corner=(-100um, -100um, 299.48um), size=(200um, 200um, 0.4um))
  Air [Air] = box(corner=(-200um, -200um, -100um), size=(400um, 400um, 1000um))
  Metal4_1 [Metal4] = polyline(z=Metal4_lower_elevation, xy in mm: (-0.032, -0.04) (0.032, -0.04) (0.032, -0.028) (-0.032, -0.028) (-0.032, -0.04), closed, covered)
  Metal4_1.sweep_along_vector((0mm, 0mm, Metal4_thickness))
  Metal4_2 [Metal4] = polyline(z=Metal4_lower_elevation, xy in mm: (-0.032, -0.04) (0.032, -0.04) (0.032, -0.028) (-0.032, -0.028) (-0.032, -0.04), closed, covered)
  Metal4_2.sweep_along_vector((0mm, 0mm, Metal4_thickness))
  Metal4_3 [Metal4] = polyline(z=Metal4_lower_elevation, xy in mm: (-0.032, 0.028) (0.032, 0.028) (0.032, 0.04) (-0.032, 0.04) (-0.032, 0.028), closed, covered)
  Metal4_3.sweep_along_vector((0mm, 0mm, Metal4_thickness))
  Metal4_4 [Metal4] = polyline(z=Metal4_lower_elevation, xy in mm: (-0.032, 0.028) (0.032, 0.028) (0.032, 0.04) (-0.032, 0.04) (-0.032, 0.028), closed, covered)
  Metal4_4.sweep_along_vector((0mm, 0mm, Metal4_thickness))
  Metal4_5 [Metal4] = polyline(z=Metal4_lower_elevation, xy in mm: (0.032, -0.04) (0.08, -0.04) (0.08, 0.04) (0.032, 0.04) (0.032, -0.04), closed, covered)
  Metal4_5.sweep_along_vector((0mm, 0mm, Metal4_thickness))
  Metal4_6 [Metal4] = polyline(z=Metal4_lower_elevation, xy in mm: (0.032, -0.04) (0.08, -0.04) (0.08, 0.04) (0.032, 0.04) (0.032, -0.04), closed, covered)
  Metal4_6.sweep_along_vector((0mm, 0mm, Metal4_thickness))
  Metal4_7 [Metal4] = polyline(z=Metal4_lower_elevation, xy in mm: (-0.08, -0.04) (-0.032, -0.04) (-0.032, 0.04) (-0.08, 0.04) (-0.08, -0.04), closed, covered)
  Metal4_7.sweep_along_vector((0mm, 0mm, Metal4_thickness))
  Metal4_8 [Metal4] = polyline(z=Metal4_lower_elevation, xy in mm: (-0.08, -0.04) (-0.032, -0.04) (-0.032, 0.04) (-0.08, 0.04) (-0.08, -0.04), closed, covered)
  Metal4_8.sweep_along_vector((0mm, 0mm, Metal4_thickness))
  Metal5_1 [Metal5] = polyline(z=Metal5_lower_elevation, xy in mm: (-0.032, -0.04) (0.032, -0.04) (0.032, -0.028) (-0.032, -0.028) (-0.032, -0.04), closed, covered)
  Metal5_1.sweep_along_vector((0mm, 0mm, Metal5_thickness))
  Metal5_2 [Metal5] = polyline(z=Metal5_lower_elevation, xy in mm: (-0.032, -0.04) (0.032, -0.04) (0.032, -0.028) (-0.032, -0.028) (-0.032, -0.04), closed, covered)
  Metal5_2.sweep_along_vector((0mm, 0mm, Metal5_thickness))
  Metal5_3 [Metal5] = polyline(z=Metal5_lower_elevation, xy in mm: (-0.032, 0.028) (0.032, 0.028) (0.032, 0.04) (-0.032, 0.04) (-0.032, 0.028), closed, covered)
  Metal5_3.sweep_along_vector((0mm, 0mm, Metal5_thickness))
  Metal5_4 [Metal5] = polyline(z=Metal5_lower_elevation, xy in mm: (-0.032, 0.028) (0.032, 0.028) (0.032, 0.04) (-0.032, 0.04) (-0.032, 0.028), closed, covered)
  Metal5_4.sweep_along_vector((0mm, 0mm, Metal5_thickness))
  Metal5_5 [Metal5] = polyline(z=Metal5_lower_elevation, xy in mm: (0.032, -0.04) (0.08, -0.04) (0.08, 0.04) (0.032, 0.04) (0.032, -0.04), closed, covered)
  Metal5_5.sweep_along_vector((0mm, 0mm, Metal5_thickness))
  Metal5_6 [Metal5] = polyline(z=Metal5_lower_elevation, xy in mm: (0.032, -0.04) (0.08, -0.04) (0.08, 0.04) (0.032, 0.04) (0.032, -0.04), closed, covered)
  Metal5_6.sweep_along_vector((0mm, 0mm, Metal5_thickness))
  Metal5_7 [Metal5] = polyline(z=Metal5_lower_elevation, xy in mm: (-0.08, -0.04) (-0.032, -0.04) (-0.032, 0.04) (-0.08, 0.04) (-0.08, -0.04), closed, covered)
  Metal5_7.sweep_along_vector((0mm, 0mm, Metal5_thickness))
  Metal5_8 [Metal5] = polyline(z=Metal5_lower_elevation, xy in mm: (-0.08, -0.04) (-0.032, -0.04) (-0.032, 0.04) (-0.08, 0.04) (-0.08, -0.04), closed, covered)
  Metal5_8.sweep_along_vector((0mm, 0mm, Metal5_thickness))
  TopMetal2_1 [TopMetal2] = polyline(z=TopMetal2_lower_elevation, xy in mm: (0.004, -0.04) (0.008, -0.04) (0.008, -0.019172) (0.006828, -0.018) (0.005172, -0.018) (0.004, -0.019172) (0.004, -0.04), closed, covered)
  TopMetal2_1.sweep_along_vector((0mm, 0mm, TopMetal2_thickness))
  TopMetal2_2 [TopMetal2] = polyline(z=TopMetal2_lower_elevation, xy in mm: (0.005172, -0.022) (0.016828, -0.022) (0.018, -0.020828) (0.018, -0.019172) (0.016828, -0.018) (0.005172, -0.018) (0.004, -0.019172) (0.004, -0.020828) (0.005172, -0.022), closed, covered)
  TopMetal2_2.sweep_along_vector((0mm, 0mm, TopMetal2_thickness))
  TopMetal2_3 [TopMetal2] = polyline(z=TopMetal2_lower_elevation, xy in mm: (0.015172, -0.022) (0.016828, -0.022) (0.022, -0.016828) (0.022, -0.015172) (0.020828, -0.014) (0.019172, -0.014) (0.014, -0.019172) (0.014, -0.020828) (0.015172, -0.022), closed, covered)
  TopMetal2_3.sweep_along_vector((0mm, 0mm, TopMetal2_thickness))
  TopMetal2_4 [TopMetal2] = polyline(z=TopMetal2_lower_elevation, xy in mm: (0.019172, -0.018) (0.020828, -0.018) (0.022, -0.016828) (0.022, 0.016828) (0.020828, 0.018) (0.019172, 0.018) (0.018, 0.016828) (0.018, -0.016828) (0.019172, -0.018), closed, covered)
  TopMetal2_4.sweep_along_vector((0mm, 0mm, TopMetal2_thickness))
  TopMetal2_5 [TopMetal2] = polyline(z=TopMetal2_lower_elevation, xy in mm: (0.019172, 0.014) (0.020828, 0.014) (0.022, 0.015172) (0.022, 0.016828) (0.016828, 0.022) (0.015172, 0.022) (0.014, 0.020828) (0.014, 0.019172) (0.019172, 0.014), closed, covered)
  TopMetal2_5.sweep_along_vector((0mm, 0mm, TopMetal2_thickness))
  TopMetal2_6 [TopMetal2] = polyline(z=TopMetal2_lower_elevation, xy in mm: (-0.016828, 0.018) (0.016828, 0.018) (0.018, 0.019172) (0.018, 0.020828) (0.016828, 0.022) (-0.016828, 0.022) (-0.018, 0.020828) (-0.018, 0.019172) (-0.016828, 0.018), closed, covered)
  TopMetal2_6.sweep_along_vector((0mm, 0mm, TopMetal2_thickness))
  TopMetal2_7 [TopMetal2] = polyline(z=TopMetal2_lower_elevation, xy in mm: (-0.020828, 0.014) (-0.019172, 0.014) (-0.014, 0.019172) (-0.014, 0.020828) (-0.015172, 0.022) (-0.016828, 0.022) (-0.022, 0.016828) (-0.022, 0.015172) (-0.020828, 0.014), closed, covered)
  TopMetal2_7.sweep_along_vector((0mm, 0mm, TopMetal2_thickness))
  TopMetal2_8 [TopMetal2] = polyline(z=TopMetal2_lower_elevation, xy in mm: (-0.020828, -0.018) (-0.019172, -0.018) (-0.018, -0.016828) (-0.018, 0.016828) (-0.019172, 0.018) (-0.020828, 0.018) (-0.022, 0.016828) (-0.022, -0.016828) (-0.020828, -0.018), closed, covered)
  TopMetal2_8.sweep_along_vector((0mm, 0mm, TopMetal2_thickness))
  TopMetal2_9 [TopMetal2] = polyline(z=TopMetal2_lower_elevation, xy in mm: (-0.016828, -0.022) (-0.015172, -0.022) (-0.014, -0.020828) (-0.014, -0.019172) (-0.019172, -0.014) (-0.020828, -0.014) (-0.022, -0.015172) (-0.022, -0.016828) (-0.016828, -0.022), closed, covered)
  TopMetal2_9.sweep_along_vector((0mm, 0mm, TopMetal2_thickness))
  TopMetal2_10 [TopMetal2] = polyline(z=TopMetal2_lower_elevation, xy in mm: (-0.016828, -0.022) (-0.005172, -0.022) (-0.004, -0.020828) (-0.004, -0.019172) (-0.005172, -0.018) (-0.016828, -0.018) (-0.018, -0.019172) (-0.018, -0.020828) (-0.016828, -0.022), closed, covered)
  TopMetal2_10.sweep_along_vector((0mm, 0mm, TopMetal2_thickness))
  TopMetal2_11 [TopMetal2] = polyline(z=TopMetal2_lower_elevation, xy in mm: (-0.008, -0.04) (-0.004, -0.04) (-0.004, -0.019172) (-0.005172, -0.018) (-0.006828, -0.018) (-0.008, -0.019172) (-0.008, -0.04), closed, covered)
  TopMetal2_11.sweep_along_vector((0mm, 0mm, TopMetal2_thickness))
  TopMetal2_12 [TopMetal2] = polyline(z=TopMetal2_lower_elevation, xy in mm: (0.004, -0.04) (0.008, -0.04) (0.008, -0.032) (0.004, -0.032) (0.004, -0.04), closed, covered)
  TopMetal2_12.sweep_along_vector((0mm, 0mm, TopMetal2_thickness))
  TopMetal2_13 [TopMetal2] = polyline(z=TopMetal2_lower_elevation, xy in mm: (-0.008, -0.04) (-0.004, -0.04) (-0.004, -0.032) (-0.008, -0.032) (-0.008, -0.04), closed, covered)
  TopMetal2_13.sweep_along_vector((0mm, 0mm, TopMetal2_thickness))
  TopMetal1_1 [TopMetal1] = polyline(z=TopMetal1_lower_elevation, xy in mm: (0.002, -0.02) (-0.002, -0.02) (-0.002, -0.032) (0.002, -0.032) (0.002, -0.02), closed, covered)
  TopMetal1_1.sweep_along_vector((0mm, 0mm, TopMetal1_thickness))
  TopMetal1_2 [TopMetal1] = polyline(z=TopMetal1_lower_elevation, xy in mm: (0.005172, 0.018) (0.006828, 0.018) (0.008, 0.019172) (0.008, 0.04) (0.004, 0.04) (0.004, 0.019172) (0.005172, 0.018), closed, covered)
  TopMetal1_2.sweep_along_vector((0mm, 0mm, TopMetal1_thickness))
  TopMetal1_3 [TopMetal1] = polyline(z=TopMetal1_lower_elevation, xy in mm: (0.005172, 0.018) (0.016828, 0.018) (0.018, 0.019172) (0.018, 0.020828) (0.016828, 0.022) (0.005172, 0.022) (0.004, 0.020828) (0.004, 0.019172) (0.005172, 0.018), closed, covered)
  TopMetal1_3.sweep_along_vector((0mm, 0mm, TopMetal1_thickness))
  TopMetal1_4 [TopMetal1] = polyline(z=TopMetal1_lower_elevation, xy in mm: (0.019172, 0.014) (0.020828, 0.014) (0.022, 0.015172) (0.022, 0.016828) (0.016828, 0.022) (0.015172, 0.022) (0.014, 0.020828) (0.014, 0.019172) (0.019172, 0.014), closed, covered)
  TopMetal1_4.sweep_along_vector((0mm, 0mm, TopMetal1_thickness))
  TopMetal1_5 [TopMetal1] = polyline(z=TopMetal1_lower_elevation, xy in mm: (0.019172, -0.018) (0.020828, -0.018) (0.022, -0.016828) (0.022, 0.016828) (0.020828, 0.018) (0.019172, 0.018) (0.018, 0.016828) (0.018, -0.016828) (0.019172, -0.018), closed, covered)
  TopMetal1_5.sweep_along_vector((0mm, 0mm, TopMetal1_thickness))
  TopMetal1_6 [TopMetal1] = polyline(z=TopMetal1_lower_elevation, xy in mm: (0.015172, -0.022) (0.016828, -0.022) (0.022, -0.016828) (0.022, -0.015172) (0.020828, -0.014) (0.019172, -0.014) (0.014, -0.019172) (0.014, -0.020828) (0.015172, -0.022), closed, covered)
  TopMetal1_6.sweep_along_vector((0mm, 0mm, TopMetal1_thickness))
  TopMetal1_7 [TopMetal1] = polyline(z=TopMetal1_lower_elevation, xy in mm: (-0.016828, -0.022) (0.016828, -0.022) (0.018, -0.020828) (0.018, -0.019172) (0.016828, -0.018) (-0.016828, -0.018) (-0.018, -0.019172) (-0.018, -0.020828) (-0.016828, -0.022), closed, covered)
  TopMetal1_7.sweep_along_vector((0mm, 0mm, TopMetal1_thickness))
  TopMetal1_8 [TopMetal1] = polyline(z=TopMetal1_lower_elevation, xy in mm: (-0.016828, -0.022) (-0.015172, -0.022) (-0.014, -0.020828) (-0.014, -0.019172) (-0.019172, -0.014) (-0.020828, -0.014) (-0.022, -0.015172) (-0.022, -0.016828) (-0.016828, -0.022), closed, covered)
  TopMetal1_8.sweep_along_vector((0mm, 0mm, TopMetal1_thickness))
  TopMetal1_9 [TopMetal1] = polyline(z=TopMetal1_lower_elevation, xy in mm: (-0.020828, -0.018) (-0.019172, -0.018) (-0.018, -0.016828) (-0.018, 0.016828) (-0.019172, 0.018) (-0.020828, 0.018) (-0.022, 0.016828) (-0.022, -0.016828) (-0.020828, -0.018), closed, covered)
  TopMetal1_9.sweep_along_vector((0mm, 0mm, TopMetal1_thickness))
  TopMetal1_10 [TopMetal1] = polyline(z=TopMetal1_lower_elevation, xy in mm: (-0.020828, 0.014) (-0.019172, 0.014) (-0.014, 0.019172) (-0.014, 0.020828) (-0.015172, 0.022) (-0.016828, 0.022) (-0.022, 0.016828) (-0.022, 0.015172) (-0.020828, 0.014), closed, covered)
  TopMetal1_10.sweep_along_vector((0mm, 0mm, TopMetal1_thickness))
  TopMetal1_11 [TopMetal1] = polyline(z=TopMetal1_lower_elevation, xy in mm: (-0.016828, 0.018) (-0.005172, 0.018) (-0.004, 0.019172) (-0.004, 0.020828) (-0.005172, 0.022) (-0.016828, 0.022) (-0.018, 0.020828) (-0.018, 0.019172) (-0.016828, 0.018), closed, covered)
  TopMetal1_11.sweep_along_vector((0mm, 0mm, TopMetal1_thickness))
  TopMetal1_12 [TopMetal1] = polyline(z=TopMetal1_lower_elevation, xy in mm: (-0.006828, 0.018) (-0.005172, 0.018) (-0.004, 0.019172) (-0.004, 0.04) (-0.008, 0.04) (-0.008, 0.019172) (-0.006828, 0.018), closed, covered)
  TopMetal1_12.sweep_along_vector((0mm, 0mm, TopMetal1_thickness))
  TopMetal1_13 [TopMetal1] = polyline(z=TopMetal1_lower_elevation, xy in mm: (-0.0015, -0.032) (0.0015, -0.032) (0.0015, -0.028) (-0.0015, -0.028) (-0.0015, -0.032), closed, covered)
  TopMetal1_13.sweep_along_vector((0mm, 0mm, TopMetal1_thickness))
  TopMetal1_14 [TopMetal1] = polyline(z=TopMetal1_lower_elevation, xy in mm: (0.004, 0.032) (0.008, 0.032) (0.008, 0.04) (0.004, 0.04) (0.004, 0.032), closed, covered)
  TopMetal1_14.sweep_along_vector((0mm, 0mm, TopMetal1_thickness))
  TopMetal1_15 [TopMetal1] = polyline(z=TopMetal1_lower_elevation, xy in mm: (-0.008, 0.032) (-0.004, 0.032) (-0.004, 0.04) (-0.008, 0.04) (-0.008, 0.032), closed, covered)
  TopMetal1_15.sweep_along_vector((0mm, 0mm, TopMetal1_thickness))
  pa = rectangle(corner=(-8um, -40um, 289.33um), z_size=5.65um, x_size=4um)
  pb = rectangle(corner=(4um, -40um, 289.33um), z_size=5.65um, x_size=4um)
  pc = rectangle(corner=(-8um, 40um, 289.33um), z_size=0.85um, x_size=4um)
  pd = rectangle(corner=(4um, 40um, 289.33um), z_size=0.85um, x_size=4um)
  ct = rectangle(corner=(-1.5um, -32um, 289.33um), z_size=0.85um, x_size=3um)
boundaries and excitations:
  Rad1: Radiation Faces=Air.face(all 6)
  1: Lumped Port Objects=pa Modes{Mode1{IntLine{middle of pa.edge(z at corner) -> middle of pa.edge(z opposite corner)} CharImp=Zpi RenormImp=50ohm}} Impedance=50ohm
  2: Lumped Port Objects=pb Modes{Mode1{IntLine{middle of pb.edge(z at corner) -> middle of pb.edge(z opposite corner)} CharImp=Zpi RenormImp=50ohm}} Impedance=50ohm
  3: Lumped Port Objects=pc Modes{Mode1{IntLine{middle of pc.edge(z at corner) -> middle of pc.edge(z opposite corner)} CharImp=Zpi RenormImp=50ohm}} Impedance=50ohm
  4: Lumped Port Objects=pd Modes{Mode1{IntLine{middle of pd.edge(z at corner) -> middle of pd.edge(z opposite corner)} CharImp=Zpi RenormImp=50ohm}} Impedance=50ohm
  5: Lumped Port Objects=ct Modes{Mode1{IntLine{middle of ct.edge(z at corner) -> middle of ct.edge(z opposite corner)} CharImp=Zpi RenormImp=50ohm}} Impedance=50ohm
setups:
  Setup1: HfssDriven Frequency=140000000000Hz MaxDeltaS=0.02 MaximumPasses=20 MinimumPasses=2 MinimumConvergedPasses=2 PercentRefinement=30 BasisOrder=2 Target=0.6667 PortAccuracy=2
    sweep Sweep1: 0Hz to 180000000000Hz step 10000000000Hz; Type=Interpolating InterpTolerance=0.5 InterpMaxSolns=250 MinSolvedFreq=0.01GHz InterpUsePortImped=false PassivityErrorTolerance=0.0001
source amplitudes:
  1:1: 1W 0deg
  2:1, 3:1, 4:1, 5:1: 0W 0deg

design XTF5PR22 (HFSS, DrivenModal, model units mm)
options: Allow_Material_Override
variables:
  extent_x_pos = 1000mm
  extent_y_pos = 1000mm
  extent_x_size = -1000mm
  extent_y_size = -1000mm
  Activ_thickness = 0.0004mm
  Activ_lower_elevation = 0.28375mm
  extent_x_pos_1 = 1000mm
  extent_y_pos_1 = 1000mm
  extent_x_size_1 = -1000mm
  extent_y_size_1 = -1000mm
  Metal1_thickness = 0.00049mm
  Metal1_lower_elevation = 0.28479mm
  extent_x_pos_2 = 1000mm
  extent_y_pos_2 = 1000mm
  extent_x_size_2 = -1000mm
  extent_y_size_2 = -1000mm
  Metal2_thickness = 0.00049mm
  Metal2_lower_elevation = 0.28575mm
  extent_x_pos_3 = 1000mm
  extent_y_pos_3 = 1000mm
  extent_x_size_3 = -1000mm
  extent_y_size_3 = -1000mm
  Metal3_thickness = 0.00049mm
  Metal3_lower_elevation = 0.28678mm
  extent_x_pos_4 = -0.08mm
  extent_y_pos_4 = -0.042mm
  extent_x_size_4 = 0.16mm
  extent_y_size_4 = 0.084mm
  Metal4_thickness = 0.00049mm
  Metal4_lower_elevation = 0.28781mm
  extent_x_pos_5 = -0.08mm
  extent_y_pos_5 = -0.042mm
  extent_x_size_5 = 0.16mm
  extent_y_size_5 = 0.084mm
  Metal5_thickness = 0.00049mm
  Metal5_lower_elevation = 0.28884mm
  extent_x_pos_6 = -0.024mm
  extent_y_pos_6 = -0.042mm
  extent_x_size_6 = 0.048mm
  extent_y_size_6 = 0.066mm
  TopMetal2_thickness = 0.003mm
  TopMetal2_lower_elevation = 0.29552mm
  extent_x_pos_7 = -0.024mm
  extent_y_pos_7 = -0.034mm
  extent_x_size_7 = 0.048mm
  extent_y_size_7 = 0.076mm
  TopMetal1_thickness = 0.002mm
  TopMetal1_lower_elevation = 0.29072mm
  extent_x_pos_8 = 1000mm
  extent_y_pos_8 = 1000mm
  extent_x_size_8 = -1000mm
  extent_y_size_8 = -1000mm
  TopVia2_thickness = 0.0028mm
  TopVia2_lower_elevation = 0.29272mm
  extent_x_pos_9 = 1000mm
  extent_y_pos_9 = 1000mm
  extent_x_size_9 = -1000mm
  extent_y_size_9 = -1000mm
  TopVia1_thickness = 0.00139mm
  TopVia1_lower_elevation = 0.28933mm
  extent_x_pos_10 = 1000mm
  extent_y_pos_10 = 1000mm
  extent_x_size_10 = -1000mm
  extent_y_size_10 = -1000mm
  Vmim_thickness = 0.00066mm
  Vmim_lower_elevation = 0.29006mm
  extent_x_pos_11 = 1000mm
  extent_y_pos_11 = 1000mm
  extent_x_size_11 = -1000mm
  extent_y_size_11 = -1000mm
  MIM_thickness = 0.00066mm
  MIM_lower_elevation = 0.28987mm
  extent_x_pos_12 = 1000mm
  extent_y_pos_12 = 1000mm
  extent_x_size_12 = -1000mm
  extent_y_size_12 = -1000mm
  Via4_thickness = 0.00054mm
  Via4_lower_elevation = 0.2883mm
  extent_x_pos_13 = 1000mm
  extent_y_pos_13 = 1000mm
  extent_x_size_13 = -1000mm
  extent_y_size_13 = -1000mm
  Via3_thickness = 0.00054mm
  Via3_lower_elevation = 0.28727mm
  extent_x_pos_14 = 1000mm
  extent_y_pos_14 = 1000mm
  extent_x_size_14 = -1000mm
  extent_y_size_14 = -1000mm
  Via2_thickness = 0.00054mm
  Via2_lower_elevation = 0.28624mm
  extent_x_pos_15 = 1000mm
  extent_y_pos_15 = 1000mm
  extent_x_size_15 = -1000mm
  extent_y_size_15 = -1000mm
  Via1_thickness = 0.00047mm
  Via1_lower_elevation = 0.28528mm
  extent_x_pos_16 = 1000mm
  extent_y_pos_16 = 1000mm
  extent_x_size_16 = -1000mm
  extent_y_size_16 = -1000mm
  Cont_thickness = 0.00064mm
  Cont_lower_elevation = 0.28415mm
geometry:
  Substrate [ihp_SI] = box(corner=(-100um, -100um, 0um), size=(200um, 200um, 280um))
  EPI [ihp_EPI] = box(corner=(-100um, -100um, 280um), size=(200um, 200um, 3.75um))
  SBM1 [ihp_SIO2] = box(corner=(-100um, -100um, 283.75um), size=(200um, 200um, 1.04um))
  SAM1 [ihp_SIO2] = box(corner=(-100um, -100um, 284.79um), size=(200um, 200um, 0.96um))
  SAM2 [ihp_SIO2] = box(corner=(-100um, -100um, 285.75um), size=(200um, 200um, 1.03um))
  SAM3 [ihp_SIO2] = box(corner=(-100um, -100um, 286.78um), size=(200um, 200um, 1.03um))
  SAM4 [ihp_SIO2] = box(corner=(-100um, -100um, 287.81um), size=(200um, 200um, 1.03um))
  SAM5 [ihp_SIO2] = box(corner=(-100um, -100um, 288.84um), size=(200um, 200um, 0.49um))
  SMIM1 [ihp_MIMD] = box(corner=(-100um, -100um, 289.33um), size=(200um, 200um, 0.04um))
  SMIM2 [ihp_SIO2] = box(corner=(-100um, -100um, 289.37um), size=(200um, 200um, 0.81um))
  TM1 [ihp_SIO2] = box(corner=(-100um, -100um, 290.18um), size=(200um, 200um, 4.8um))
  TM2 [ihp_SIO2] = box(corner=(-100um, -100um, 294.98um), size=(200um, 200um, 4.5um))
  PSV [ihp_PSV] = box(corner=(-100um, -100um, 299.48um), size=(200um, 200um, 0.4um))
  Air [Air] = box(corner=(-200um, -200um, -100um), size=(400um, 400um, 1000um))
  Metal4_1 [Metal4] = polyline(z=Metal4_lower_elevation, xy in mm: (-0.034, -0.042) (0.034, -0.042) (0.034, -0.03) (-0.034, -0.03) (-0.034, -0.042), closed, covered)
  Metal4_1.sweep_along_vector((0mm, 0mm, Metal4_thickness))
  Metal4_2 [Metal4] = polyline(z=Metal4_lower_elevation, xy in mm: (-0.034, -0.042) (0.034, -0.042) (0.034, -0.03) (-0.034, -0.03) (-0.034, -0.042), closed, covered)
  Metal4_2.sweep_along_vector((0mm, 0mm, Metal4_thickness))
  Metal4_3 [Metal4] = polyline(z=Metal4_lower_elevation, xy in mm: (-0.034, 0.03) (0.034, 0.03) (0.034, 0.042) (-0.034, 0.042) (-0.034, 0.03), closed, covered)
  Metal4_3.sweep_along_vector((0mm, 0mm, Metal4_thickness))
  Metal4_4 [Metal4] = polyline(z=Metal4_lower_elevation, xy in mm: (-0.034, 0.03) (0.034, 0.03) (0.034, 0.042) (-0.034, 0.042) (-0.034, 0.03), closed, covered)
  Metal4_4.sweep_along_vector((0mm, 0mm, Metal4_thickness))
  Metal4_5 [Metal4] = polyline(z=Metal4_lower_elevation, xy in mm: (0.034, -0.042) (0.08, -0.042) (0.08, 0.042) (0.034, 0.042) (0.034, -0.042), closed, covered)
  Metal4_5.sweep_along_vector((0mm, 0mm, Metal4_thickness))
  Metal4_6 [Metal4] = polyline(z=Metal4_lower_elevation, xy in mm: (0.034, -0.042) (0.08, -0.042) (0.08, 0.042) (0.034, 0.042) (0.034, -0.042), closed, covered)
  Metal4_6.sweep_along_vector((0mm, 0mm, Metal4_thickness))
  Metal4_7 [Metal4] = polyline(z=Metal4_lower_elevation, xy in mm: (-0.08, -0.042) (-0.034, -0.042) (-0.034, 0.042) (-0.08, 0.042) (-0.08, -0.042), closed, covered)
  Metal4_7.sweep_along_vector((0mm, 0mm, Metal4_thickness))
  Metal4_8 [Metal4] = polyline(z=Metal4_lower_elevation, xy in mm: (-0.08, -0.042) (-0.034, -0.042) (-0.034, 0.042) (-0.08, 0.042) (-0.08, -0.042), closed, covered)
  Metal4_8.sweep_along_vector((0mm, 0mm, Metal4_thickness))
  Metal5_1 [Metal5] = polyline(z=Metal5_lower_elevation, xy in mm: (-0.034, -0.042) (0.034, -0.042) (0.034, -0.03) (-0.034, -0.03) (-0.034, -0.042), closed, covered)
  Metal5_1.sweep_along_vector((0mm, 0mm, Metal5_thickness))
  Metal5_2 [Metal5] = polyline(z=Metal5_lower_elevation, xy in mm: (-0.034, -0.042) (0.034, -0.042) (0.034, -0.03) (-0.034, -0.03) (-0.034, -0.042), closed, covered)
  Metal5_2.sweep_along_vector((0mm, 0mm, Metal5_thickness))
  Metal5_3 [Metal5] = polyline(z=Metal5_lower_elevation, xy in mm: (-0.034, 0.03) (0.034, 0.03) (0.034, 0.042) (-0.034, 0.042) (-0.034, 0.03), closed, covered)
  Metal5_3.sweep_along_vector((0mm, 0mm, Metal5_thickness))
  Metal5_4 [Metal5] = polyline(z=Metal5_lower_elevation, xy in mm: (-0.034, 0.03) (0.034, 0.03) (0.034, 0.042) (-0.034, 0.042) (-0.034, 0.03), closed, covered)
  Metal5_4.sweep_along_vector((0mm, 0mm, Metal5_thickness))
  Metal5_5 [Metal5] = polyline(z=Metal5_lower_elevation, xy in mm: (0.034, -0.042) (0.08, -0.042) (0.08, 0.042) (0.034, 0.042) (0.034, -0.042), closed, covered)
  Metal5_5.sweep_along_vector((0mm, 0mm, Metal5_thickness))
  Metal5_6 [Metal5] = polyline(z=Metal5_lower_elevation, xy in mm: (0.034, -0.042) (0.08, -0.042) (0.08, 0.042) (0.034, 0.042) (0.034, -0.042), closed, covered)
  Metal5_6.sweep_along_vector((0mm, 0mm, Metal5_thickness))
  Metal5_7 [Metal5] = polyline(z=Metal5_lower_elevation, xy in mm: (-0.08, -0.042) (-0.034, -0.042) (-0.034, 0.042) (-0.08, 0.042) (-0.08, -0.042), closed, covered)
  Metal5_7.sweep_along_vector((0mm, 0mm, Metal5_thickness))
  Metal5_8 [Metal5] = polyline(z=Metal5_lower_elevation, xy in mm: (-0.08, -0.042) (-0.034, -0.042) (-0.034, 0.042) (-0.08, 0.042) (-0.08, -0.042), closed, covered)
  Metal5_8.sweep_along_vector((0mm, 0mm, Metal5_thickness))
  TopMetal2_1 [TopMetal2] = polyline(z=TopMetal2_lower_elevation, xy in mm: (0.004, -0.042) (0.008, -0.042) (0.008, -0.021172) (0.006828, -0.02) (0.005172, -0.02) (0.004, -0.021172) (0.004, -0.042), closed, covered)
  TopMetal2_1.sweep_along_vector((0mm, 0mm, TopMetal2_thickness))
  TopMetal2_2 [TopMetal2] = polyline(z=TopMetal2_lower_elevation, xy in mm: (0.005172, -0.024) (0.018828, -0.024) (0.02, -0.022828) (0.02, -0.021172) (0.018828, -0.02) (0.005172, -0.02) (0.004, -0.021172) (0.004, -0.022828) (0.005172, -0.024), closed, covered)
  TopMetal2_2.sweep_along_vector((0mm, 0mm, TopMetal2_thickness))
  TopMetal2_3 [TopMetal2] = polyline(z=TopMetal2_lower_elevation, xy in mm: (0.017172, -0.024) (0.018828, -0.024) (0.024, -0.018828) (0.024, -0.017172) (0.022828, -0.016) (0.021172, -0.016) (0.016, -0.021172) (0.016, -0.022828) (0.017172, -0.024), closed, covered)
  TopMetal2_3.sweep_along_vector((0mm, 0mm, TopMetal2_thickness))
  TopMetal2_4 [TopMetal2] = polyline(z=TopMetal2_lower_elevation, xy in mm: (0.021172, -0.02) (0.022828, -0.02) (0.024, -0.018828) (0.024, 0.018828) (0.022828, 0.02) (0.021172, 0.02) (0.02, 0.018828) (0.02, -0.018828) (0.021172, -0.02), closed, covered)
  TopMetal2_4.sweep_along_vector((0mm, 0mm, TopMetal2_thickness))
  TopMetal2_5 [TopMetal2] = polyline(z=TopMetal2_lower_elevation, xy in mm: (0.021172, 0.016) (0.022828, 0.016) (0.024, 0.017172) (0.024, 0.018828) (0.018828, 0.024) (0.017172, 0.024) (0.016, 0.022828) (0.016, 0.021172) (0.021172, 0.016), closed, covered)
  TopMetal2_5.sweep_along_vector((0mm, 0mm, TopMetal2_thickness))
  TopMetal2_6 [TopMetal2] = polyline(z=TopMetal2_lower_elevation, xy in mm: (-0.018828, 0.02) (0.018828, 0.02) (0.02, 0.021172) (0.02, 0.022828) (0.018828, 0.024) (-0.018828, 0.024) (-0.02, 0.022828) (-0.02, 0.021172) (-0.018828, 0.02), closed, covered)
  TopMetal2_6.sweep_along_vector((0mm, 0mm, TopMetal2_thickness))
  TopMetal2_7 [TopMetal2] = polyline(z=TopMetal2_lower_elevation, xy in mm: (-0.022828, 0.016) (-0.021172, 0.016) (-0.016, 0.021172) (-0.016, 0.022828) (-0.017172, 0.024) (-0.018828, 0.024) (-0.024, 0.018828) (-0.024, 0.017172) (-0.022828, 0.016), closed, covered)
  TopMetal2_7.sweep_along_vector((0mm, 0mm, TopMetal2_thickness))
  TopMetal2_8 [TopMetal2] = polyline(z=TopMetal2_lower_elevation, xy in mm: (-0.022828, -0.02) (-0.021172, -0.02) (-0.02, -0.018828) (-0.02, 0.018828) (-0.021172, 0.02) (-0.022828, 0.02) (-0.024, 0.018828) (-0.024, -0.018828) (-0.022828, -0.02), closed, covered)
  TopMetal2_8.sweep_along_vector((0mm, 0mm, TopMetal2_thickness))
  TopMetal2_9 [TopMetal2] = polyline(z=TopMetal2_lower_elevation, xy in mm: (-0.018828, -0.024) (-0.017172, -0.024) (-0.016, -0.022828) (-0.016, -0.021172) (-0.021172, -0.016) (-0.022828, -0.016) (-0.024, -0.017172) (-0.024, -0.018828) (-0.018828, -0.024), closed, covered)
  TopMetal2_9.sweep_along_vector((0mm, 0mm, TopMetal2_thickness))
  TopMetal2_10 [TopMetal2] = polyline(z=TopMetal2_lower_elevation, xy in mm: (-0.018828, -0.024) (-0.005172, -0.024) (-0.004, -0.022828) (-0.004, -0.021172) (-0.005172, -0.02) (-0.018828, -0.02) (-0.02, -0.021172) (-0.02, -0.022828) (-0.018828, -0.024), closed, covered)
  TopMetal2_10.sweep_along_vector((0mm, 0mm, TopMetal2_thickness))
  TopMetal2_11 [TopMetal2] = polyline(z=TopMetal2_lower_elevation, xy in mm: (-0.008, -0.042) (-0.004, -0.042) (-0.004, -0.021172) (-0.005172, -0.02) (-0.006828, -0.02) (-0.008, -0.021172) (-0.008, -0.042), closed, covered)
  TopMetal2_11.sweep_along_vector((0mm, 0mm, TopMetal2_thickness))
  TopMetal2_12 [TopMetal2] = polyline(z=TopMetal2_lower_elevation, xy in mm: (0.004, -0.042) (0.008, -0.042) (0.008, -0.034) (0.004, -0.034) (0.004, -0.042), closed, covered)
  TopMetal2_12.sweep_along_vector((0mm, 0mm, TopMetal2_thickness))
  TopMetal2_13 [TopMetal2] = polyline(z=TopMetal2_lower_elevation, xy in mm: (-0.008, -0.042) (-0.004, -0.042) (-0.004, -0.034) (-0.008, -0.034) (-0.008, -0.042), closed, covered)
  TopMetal2_13.sweep_along_vector((0mm, 0mm, TopMetal2_thickness))
  TopMetal1_1 [TopMetal1] = polyline(z=TopMetal1_lower_elevation, xy in mm: (0.002, -0.022) (-0.002, -0.022) (-0.002, -0.034) (0.002, -0.034) (0.002, -0.022), closed, covered)
  TopMetal1_1.sweep_along_vector((0mm, 0mm, TopMetal1_thickness))
  TopMetal1_2 [TopMetal1] = polyline(z=TopMetal1_lower_elevation, xy in mm: (0.005172, 0.02) (0.006828, 0.02) (0.008, 0.021172) (0.008, 0.042) (0.004, 0.042) (0.004, 0.021172) (0.005172, 0.02), closed, covered)
  TopMetal1_2.sweep_along_vector((0mm, 0mm, TopMetal1_thickness))
  TopMetal1_3 [TopMetal1] = polyline(z=TopMetal1_lower_elevation, xy in mm: (0.005172, 0.02) (0.018828, 0.02) (0.02, 0.021172) (0.02, 0.022828) (0.018828, 0.024) (0.005172, 0.024) (0.004, 0.022828) (0.004, 0.021172) (0.005172, 0.02), closed, covered)
  TopMetal1_3.sweep_along_vector((0mm, 0mm, TopMetal1_thickness))
  TopMetal1_4 [TopMetal1] = polyline(z=TopMetal1_lower_elevation, xy in mm: (0.021172, 0.016) (0.022828, 0.016) (0.024, 0.017172) (0.024, 0.018828) (0.018828, 0.024) (0.017172, 0.024) (0.016, 0.022828) (0.016, 0.021172) (0.021172, 0.016), closed, covered)
  TopMetal1_4.sweep_along_vector((0mm, 0mm, TopMetal1_thickness))
  TopMetal1_5 [TopMetal1] = polyline(z=TopMetal1_lower_elevation, xy in mm: (0.021172, -0.02) (0.022828, -0.02) (0.024, -0.018828) (0.024, 0.018828) (0.022828, 0.02) (0.021172, 0.02) (0.02, 0.018828) (0.02, -0.018828) (0.021172, -0.02), closed, covered)
  TopMetal1_5.sweep_along_vector((0mm, 0mm, TopMetal1_thickness))
  TopMetal1_6 [TopMetal1] = polyline(z=TopMetal1_lower_elevation, xy in mm: (0.017172, -0.024) (0.018828, -0.024) (0.024, -0.018828) (0.024, -0.017172) (0.022828, -0.016) (0.021172, -0.016) (0.016, -0.021172) (0.016, -0.022828) (0.017172, -0.024), closed, covered)
  TopMetal1_6.sweep_along_vector((0mm, 0mm, TopMetal1_thickness))
  TopMetal1_7 [TopMetal1] = polyline(z=TopMetal1_lower_elevation, xy in mm: (-0.018828, -0.024) (0.018828, -0.024) (0.02, -0.022828) (0.02, -0.021172) (0.018828, -0.02) (-0.018828, -0.02) (-0.02, -0.021172) (-0.02, -0.022828) (-0.018828, -0.024), closed, covered)
  TopMetal1_7.sweep_along_vector((0mm, 0mm, TopMetal1_thickness))
  TopMetal1_8 [TopMetal1] = polyline(z=TopMetal1_lower_elevation, xy in mm: (-0.018828, -0.024) (-0.017172, -0.024) (-0.016, -0.022828) (-0.016, -0.021172) (-0.021172, -0.016) (-0.022828, -0.016) (-0.024, -0.017172) (-0.024, -0.018828) (-0.018828, -0.024), closed, covered)
  TopMetal1_8.sweep_along_vector((0mm, 0mm, TopMetal1_thickness))
  TopMetal1_9 [TopMetal1] = polyline(z=TopMetal1_lower_elevation, xy in mm: (-0.022828, -0.02) (-0.021172, -0.02) (-0.02, -0.018828) (-0.02, 0.018828) (-0.021172, 0.02) (-0.022828, 0.02) (-0.024, 0.018828) (-0.024, -0.018828) (-0.022828, -0.02), closed, covered)
  TopMetal1_9.sweep_along_vector((0mm, 0mm, TopMetal1_thickness))
  TopMetal1_10 [TopMetal1] = polyline(z=TopMetal1_lower_elevation, xy in mm: (-0.022828, 0.016) (-0.021172, 0.016) (-0.016, 0.021172) (-0.016, 0.022828) (-0.017172, 0.024) (-0.018828, 0.024) (-0.024, 0.018828) (-0.024, 0.017172) (-0.022828, 0.016), closed, covered)
  TopMetal1_10.sweep_along_vector((0mm, 0mm, TopMetal1_thickness))
  TopMetal1_11 [TopMetal1] = polyline(z=TopMetal1_lower_elevation, xy in mm: (-0.018828, 0.02) (-0.005172, 0.02) (-0.004, 0.021172) (-0.004, 0.022828) (-0.005172, 0.024) (-0.018828, 0.024) (-0.02, 0.022828) (-0.02, 0.021172) (-0.018828, 0.02), closed, covered)
  TopMetal1_11.sweep_along_vector((0mm, 0mm, TopMetal1_thickness))
  TopMetal1_12 [TopMetal1] = polyline(z=TopMetal1_lower_elevation, xy in mm: (-0.006828, 0.02) (-0.005172, 0.02) (-0.004, 0.021172) (-0.004, 0.042) (-0.008, 0.042) (-0.008, 0.021172) (-0.006828, 0.02), closed, covered)
  TopMetal1_12.sweep_along_vector((0mm, 0mm, TopMetal1_thickness))
  TopMetal1_13 [TopMetal1] = polyline(z=TopMetal1_lower_elevation, xy in mm: (-0.0015, -0.034) (0.0015, -0.034) (0.0015, -0.03) (-0.0015, -0.03) (-0.0015, -0.034), closed, covered)
  TopMetal1_13.sweep_along_vector((0mm, 0mm, TopMetal1_thickness))
  TopMetal1_14 [TopMetal1] = polyline(z=TopMetal1_lower_elevation, xy in mm: (0.004, 0.034) (0.008, 0.034) (0.008, 0.042) (0.004, 0.042) (0.004, 0.034), closed, covered)
  TopMetal1_14.sweep_along_vector((0mm, 0mm, TopMetal1_thickness))
  TopMetal1_15 [TopMetal1] = polyline(z=TopMetal1_lower_elevation, xy in mm: (-0.008, 0.034) (-0.004, 0.034) (-0.004, 0.042) (-0.008, 0.042) (-0.008, 0.034), closed, covered)
  TopMetal1_15.sweep_along_vector((0mm, 0mm, TopMetal1_thickness))
  pa = rectangle(corner=(-8um, -42um, 289.33um), z_size=5.65um, x_size=4um)
  pb = rectangle(corner=(4um, -42um, 289.33um), z_size=5.65um, x_size=4um)
  pc = rectangle(corner=(-8um, 42um, 289.33um), z_size=0.85um, x_size=4um)
  pd = rectangle(corner=(4um, 42um, 289.33um), z_size=0.85um, x_size=4um)
  ct = rectangle(corner=(-1.5um, -34um, 289.33um), z_size=0.85um, x_size=3um)
boundaries and excitations:
  Rad1: Radiation Faces=Air.face(all 6)
  1: Lumped Port Objects=pa Modes{Mode1{IntLine{middle of pa.edge(z at corner) -> middle of pa.edge(z opposite corner)} CharImp=Zpi RenormImp=50ohm}} Impedance=50ohm
  2: Lumped Port Objects=pb Modes{Mode1{IntLine{middle of pb.edge(z at corner) -> middle of pb.edge(z opposite corner)} CharImp=Zpi RenormImp=50ohm}} Impedance=50ohm
  3: Lumped Port Objects=pc Modes{Mode1{IntLine{middle of pc.edge(z at corner) -> middle of pc.edge(z opposite corner)} CharImp=Zpi RenormImp=50ohm}} Impedance=50ohm
  4: Lumped Port Objects=pd Modes{Mode1{IntLine{middle of pd.edge(z at corner) -> middle of pd.edge(z opposite corner)} CharImp=Zpi RenormImp=50ohm}} Impedance=50ohm
  5: Lumped Port Objects=ct Modes{Mode1{IntLine{middle of ct.edge(z at corner) -> middle of ct.edge(z opposite corner)} CharImp=Zpi RenormImp=50ohm}} Impedance=50ohm
setups:
  Setup1: HfssDriven Frequency=140000000000Hz MaxDeltaS=0.02 MaximumPasses=20 MinimumPasses=2 MinimumConvergedPasses=2 PercentRefinement=30 BasisOrder=2 Target=0.6667 PortAccuracy=2
    sweep Sweep1: 0Hz to 180000000000Hz step 10000000000Hz; Type=Interpolating InterpTolerance=0.5 InterpMaxSolns=250 MinSolvedFreq=0.01GHz InterpUsePortImped=false PassivityErrorTolerance=0.0001
source amplitudes:
  1:1: 1W 0deg
  2:1, 3:1, 4:1, 5:1: 0W 0deg

design XTF5PR24 (HFSS, DrivenModal, model units mm)
options: Allow_Material_Override
variables:
  extent_x_pos = 1000mm
  extent_y_pos = 1000mm
  extent_x_size = -1000mm
  extent_y_size = -1000mm
  Activ_thickness = 0.0004mm
  Activ_lower_elevation = 0.28375mm
  extent_x_pos_1 = 1000mm
  extent_y_pos_1 = 1000mm
  extent_x_size_1 = -1000mm
  extent_y_size_1 = -1000mm
  Metal1_thickness = 0.00049mm
  Metal1_lower_elevation = 0.28479mm
  extent_x_pos_2 = 1000mm
  extent_y_pos_2 = 1000mm
  extent_x_size_2 = -1000mm
  extent_y_size_2 = -1000mm
  Metal2_thickness = 0.00049mm
  Metal2_lower_elevation = 0.28575mm
  extent_x_pos_3 = 1000mm
  extent_y_pos_3 = 1000mm
  extent_x_size_3 = -1000mm
  extent_y_size_3 = -1000mm
  Metal3_thickness = 0.00049mm
  Metal3_lower_elevation = 0.28678mm
  extent_x_pos_4 = -0.08mm
  extent_y_pos_4 = -0.044mm
  extent_x_size_4 = 0.16mm
  extent_y_size_4 = 0.088mm
  Metal4_thickness = 0.00049mm
  Metal4_lower_elevation = 0.28781mm
  extent_x_pos_5 = -0.08mm
  extent_y_pos_5 = -0.044mm
  extent_x_size_5 = 0.16mm
  extent_y_size_5 = 0.088mm
  Metal5_thickness = 0.00049mm
  Metal5_lower_elevation = 0.28884mm
  extent_x_pos_6 = -0.026mm
  extent_y_pos_6 = -0.044mm
  extent_x_size_6 = 0.052mm
  extent_y_size_6 = 0.07mm
  TopMetal2_thickness = 0.003mm
  TopMetal2_lower_elevation = 0.29552mm
  extent_x_pos_7 = -0.026mm
  extent_y_pos_7 = -0.036mm
  extent_x_size_7 = 0.052mm
  extent_y_size_7 = 0.08mm
  TopMetal1_thickness = 0.002mm
  TopMetal1_lower_elevation = 0.29072mm
  extent_x_pos_8 = 1000mm
  extent_y_pos_8 = 1000mm
  extent_x_size_8 = -1000mm
  extent_y_size_8 = -1000mm
  TopVia2_thickness = 0.0028mm
  TopVia2_lower_elevation = 0.29272mm
  extent_x_pos_9 = 1000mm
  extent_y_pos_9 = 1000mm
  extent_x_size_9 = -1000mm
  extent_y_size_9 = -1000mm
  TopVia1_thickness = 0.00139mm
  TopVia1_lower_elevation = 0.28933mm
  extent_x_pos_10 = 1000mm
  extent_y_pos_10 = 1000mm
  extent_x_size_10 = -1000mm
  extent_y_size_10 = -1000mm
  Vmim_thickness = 0.00066mm
  Vmim_lower_elevation = 0.29006mm
  extent_x_pos_11 = 1000mm
  extent_y_pos_11 = 1000mm
  extent_x_size_11 = -1000mm
  extent_y_size_11 = -1000mm
  MIM_thickness = 0.00066mm
  MIM_lower_elevation = 0.28987mm
  extent_x_pos_12 = 1000mm
  extent_y_pos_12 = 1000mm
  extent_x_size_12 = -1000mm
  extent_y_size_12 = -1000mm
  Via4_thickness = 0.00054mm
  Via4_lower_elevation = 0.2883mm
  extent_x_pos_13 = 1000mm
  extent_y_pos_13 = 1000mm
  extent_x_size_13 = -1000mm
  extent_y_size_13 = -1000mm
  Via3_thickness = 0.00054mm
  Via3_lower_elevation = 0.28727mm
  extent_x_pos_14 = 1000mm
  extent_y_pos_14 = 1000mm
  extent_x_size_14 = -1000mm
  extent_y_size_14 = -1000mm
  Via2_thickness = 0.00054mm
  Via2_lower_elevation = 0.28624mm
  extent_x_pos_15 = 1000mm
  extent_y_pos_15 = 1000mm
  extent_x_size_15 = -1000mm
  extent_y_size_15 = -1000mm
  Via1_thickness = 0.00047mm
  Via1_lower_elevation = 0.28528mm
  extent_x_pos_16 = 1000mm
  extent_y_pos_16 = 1000mm
  extent_x_size_16 = -1000mm
  extent_y_size_16 = -1000mm
  Cont_thickness = 0.00064mm
  Cont_lower_elevation = 0.28415mm
geometry:
  Substrate [ihp_SI] = box(corner=(-100um, -100um, 0um), size=(200um, 200um, 280um))
  EPI [ihp_EPI] = box(corner=(-100um, -100um, 280um), size=(200um, 200um, 3.75um))
  SBM1 [ihp_SIO2] = box(corner=(-100um, -100um, 283.75um), size=(200um, 200um, 1.04um))
  SAM1 [ihp_SIO2] = box(corner=(-100um, -100um, 284.79um), size=(200um, 200um, 0.96um))
  SAM2 [ihp_SIO2] = box(corner=(-100um, -100um, 285.75um), size=(200um, 200um, 1.03um))
  SAM3 [ihp_SIO2] = box(corner=(-100um, -100um, 286.78um), size=(200um, 200um, 1.03um))
  SAM4 [ihp_SIO2] = box(corner=(-100um, -100um, 287.81um), size=(200um, 200um, 1.03um))
  SAM5 [ihp_SIO2] = box(corner=(-100um, -100um, 288.84um), size=(200um, 200um, 0.49um))
  SMIM1 [ihp_MIMD] = box(corner=(-100um, -100um, 289.33um), size=(200um, 200um, 0.04um))
  SMIM2 [ihp_SIO2] = box(corner=(-100um, -100um, 289.37um), size=(200um, 200um, 0.81um))
  TM1 [ihp_SIO2] = box(corner=(-100um, -100um, 290.18um), size=(200um, 200um, 4.8um))
  TM2 [ihp_SIO2] = box(corner=(-100um, -100um, 294.98um), size=(200um, 200um, 4.5um))
  PSV [ihp_PSV] = box(corner=(-100um, -100um, 299.48um), size=(200um, 200um, 0.4um))
  Air [Air] = box(corner=(-200um, -200um, -100um), size=(400um, 400um, 1000um))
  Metal4_1 [Metal4] = polyline(z=Metal4_lower_elevation, xy in mm: (-0.036, -0.044) (0.036, -0.044) (0.036, -0.032) (-0.036, -0.032) (-0.036, -0.044), closed, covered)
  Metal4_1.sweep_along_vector((0mm, 0mm, Metal4_thickness))
  Metal4_2 [Metal4] = polyline(z=Metal4_lower_elevation, xy in mm: (-0.036, -0.044) (0.036, -0.044) (0.036, -0.032) (-0.036, -0.032) (-0.036, -0.044), closed, covered)
  Metal4_2.sweep_along_vector((0mm, 0mm, Metal4_thickness))
  Metal4_3 [Metal4] = polyline(z=Metal4_lower_elevation, xy in mm: (-0.036, 0.032) (0.036, 0.032) (0.036, 0.044) (-0.036, 0.044) (-0.036, 0.032), closed, covered)
  Metal4_3.sweep_along_vector((0mm, 0mm, Metal4_thickness))
  Metal4_4 [Metal4] = polyline(z=Metal4_lower_elevation, xy in mm: (-0.036, 0.032) (0.036, 0.032) (0.036, 0.044) (-0.036, 0.044) (-0.036, 0.032), closed, covered)
  Metal4_4.sweep_along_vector((0mm, 0mm, Metal4_thickness))
  Metal4_5 [Metal4] = polyline(z=Metal4_lower_elevation, xy in mm: (0.036, -0.044) (0.08, -0.044) (0.08, 0.044) (0.036, 0.044) (0.036, -0.044), closed, covered)
  Metal4_5.sweep_along_vector((0mm, 0mm, Metal4_thickness))
  Metal4_6 [Metal4] = polyline(z=Metal4_lower_elevation, xy in mm: (0.036, -0.044) (0.08, -0.044) (0.08, 0.044) (0.036, 0.044) (0.036, -0.044), closed, covered)
  Metal4_6.sweep_along_vector((0mm, 0mm, Metal4_thickness))
  Metal4_7 [Metal4] = polyline(z=Metal4_lower_elevation, xy in mm: (-0.08, -0.044) (-0.036, -0.044) (-0.036, 0.044) (-0.08, 0.044) (-0.08, -0.044), closed, covered)
  Metal4_7.sweep_along_vector((0mm, 0mm, Metal4_thickness))
  Metal4_8 [Metal4] = polyline(z=Metal4_lower_elevation, xy in mm: (-0.08, -0.044) (-0.036, -0.044) (-0.036, 0.044) (-0.08, 0.044) (-0.08, -0.044), closed, covered)
  Metal4_8.sweep_along_vector((0mm, 0mm, Metal4_thickness))
  Metal5_1 [Metal5] = polyline(z=Metal5_lower_elevation, xy in mm: (-0.036, -0.044) (0.036, -0.044) (0.036, -0.032) (-0.036, -0.032) (-0.036, -0.044), closed, covered)
  Metal5_1.sweep_along_vector((0mm, 0mm, Metal5_thickness))
  Metal5_2 [Metal5] = polyline(z=Metal5_lower_elevation, xy in mm: (-0.036, -0.044) (0.036, -0.044) (0.036, -0.032) (-0.036, -0.032) (-0.036, -0.044), closed, covered)
  Metal5_2.sweep_along_vector((0mm, 0mm, Metal5_thickness))
  Metal5_3 [Metal5] = polyline(z=Metal5_lower_elevation, xy in mm: (-0.036, 0.032) (0.036, 0.032) (0.036, 0.044) (-0.036, 0.044) (-0.036, 0.032), closed, covered)
  Metal5_3.sweep_along_vector((0mm, 0mm, Metal5_thickness))
  Metal5_4 [Metal5] = polyline(z=Metal5_lower_elevation, xy in mm: (-0.036, 0.032) (0.036, 0.032) (0.036, 0.044) (-0.036, 0.044) (-0.036, 0.032), closed, covered)
  Metal5_4.sweep_along_vector((0mm, 0mm, Metal5_thickness))
  Metal5_5 [Metal5] = polyline(z=Metal5_lower_elevation, xy in mm: (0.036, -0.044) (0.08, -0.044) (0.08, 0.044) (0.036, 0.044) (0.036, -0.044), closed, covered)
  Metal5_5.sweep_along_vector((0mm, 0mm, Metal5_thickness))
  Metal5_6 [Metal5] = polyline(z=Metal5_lower_elevation, xy in mm: (0.036, -0.044) (0.08, -0.044) (0.08, 0.044) (0.036, 0.044) (0.036, -0.044), closed, covered)
  Metal5_6.sweep_along_vector((0mm, 0mm, Metal5_thickness))
  Metal5_7 [Metal5] = polyline(z=Metal5_lower_elevation, xy in mm: (-0.08, -0.044) (-0.036, -0.044) (-0.036, 0.044) (-0.08, 0.044) (-0.08, -0.044), closed, covered)
  Metal5_7.sweep_along_vector((0mm, 0mm, Metal5_thickness))
  Metal5_8 [Metal5] = polyline(z=Metal5_lower_elevation, xy in mm: (-0.08, -0.044) (-0.036, -0.044) (-0.036, 0.044) (-0.08, 0.044) (-0.08, -0.044), closed, covered)
  Metal5_8.sweep_along_vector((0mm, 0mm, Metal5_thickness))
  TopMetal2_1 [TopMetal2] = polyline(z=TopMetal2_lower_elevation, xy in mm: (0.004, -0.044) (0.008, -0.044) (0.008, -0.023172) (0.006828, -0.022) (0.005172, -0.022) (0.004, -0.023172) (0.004, -0.044), closed, covered)
  TopMetal2_1.sweep_along_vector((0mm, 0mm, TopMetal2_thickness))
  TopMetal2_2 [TopMetal2] = polyline(z=TopMetal2_lower_elevation, xy in mm: (0.005172, -0.026) (0.020828, -0.026) (0.022, -0.024828) (0.022, -0.023172) (0.020828, -0.022) (0.005172, -0.022) (0.004, -0.023172) (0.004, -0.024828) (0.005172, -0.026), closed, covered)
  TopMetal2_2.sweep_along_vector((0mm, 0mm, TopMetal2_thickness))
  TopMetal2_3 [TopMetal2] = polyline(z=TopMetal2_lower_elevation, xy in mm: (0.019172, -0.026) (0.020828, -0.026) (0.026, -0.020828) (0.026, -0.019172) (0.024828, -0.018) (0.023172, -0.018) (0.018, -0.023172) (0.018, -0.024828) (0.019172, -0.026), closed, covered)
  TopMetal2_3.sweep_along_vector((0mm, 0mm, TopMetal2_thickness))
  TopMetal2_4 [TopMetal2] = polyline(z=TopMetal2_lower_elevation, xy in mm: (0.023172, -0.022) (0.024828, -0.022) (0.026, -0.020828) (0.026, 0.020828) (0.024828, 0.022) (0.023172, 0.022) (0.022, 0.020828) (0.022, -0.020828) (0.023172, -0.022), closed, covered)
  TopMetal2_4.sweep_along_vector((0mm, 0mm, TopMetal2_thickness))
  TopMetal2_5 [TopMetal2] = polyline(z=TopMetal2_lower_elevation, xy in mm: (0.023172, 0.018) (0.024828, 0.018) (0.026, 0.019172) (0.026, 0.020828) (0.020828, 0.026) (0.019172, 0.026) (0.018, 0.024828) (0.018, 0.023172) (0.023172, 0.018), closed, covered)
  TopMetal2_5.sweep_along_vector((0mm, 0mm, TopMetal2_thickness))
  TopMetal2_6 [TopMetal2] = polyline(z=TopMetal2_lower_elevation, xy in mm: (-0.020828, 0.022) (0.020828, 0.022) (0.022, 0.023172) (0.022, 0.024828) (0.020828, 0.026) (-0.020828, 0.026) (-0.022, 0.024828) (-0.022, 0.023172) (-0.020828, 0.022), closed, covered)
  TopMetal2_6.sweep_along_vector((0mm, 0mm, TopMetal2_thickness))
  TopMetal2_7 [TopMetal2] = polyline(z=TopMetal2_lower_elevation, xy in mm: (-0.024828, 0.018) (-0.023172, 0.018) (-0.018, 0.023172) (-0.018, 0.024828) (-0.019172, 0.026) (-0.020828, 0.026) (-0.026, 0.020828) (-0.026, 0.019172) (-0.024828, 0.018), closed, covered)
  TopMetal2_7.sweep_along_vector((0mm, 0mm, TopMetal2_thickness))
  TopMetal2_8 [TopMetal2] = polyline(z=TopMetal2_lower_elevation, xy in mm: (-0.024828, -0.022) (-0.023172, -0.022) (-0.022, -0.020828) (-0.022, 0.020828) (-0.023172, 0.022) (-0.024828, 0.022) (-0.026, 0.020828) (-0.026, -0.020828) (-0.024828, -0.022), closed, covered)
  TopMetal2_8.sweep_along_vector((0mm, 0mm, TopMetal2_thickness))
  TopMetal2_9 [TopMetal2] = polyline(z=TopMetal2_lower_elevation, xy in mm: (-0.020828, -0.026) (-0.019172, -0.026) (-0.018, -0.024828) (-0.018, -0.023172) (-0.023172, -0.018) (-0.024828, -0.018) (-0.026, -0.019172) (-0.026, -0.020828) (-0.020828, -0.026), closed, covered)
  TopMetal2_9.sweep_along_vector((0mm, 0mm, TopMetal2_thickness))
  TopMetal2_10 [TopMetal2] = polyline(z=TopMetal2_lower_elevation, xy in mm: (-0.020828, -0.026) (-0.005172, -0.026) (-0.004, -0.024828) (-0.004, -0.023172) (-0.005172, -0.022) (-0.020828, -0.022) (-0.022, -0.023172) (-0.022, -0.024828) (-0.020828, -0.026), closed, covered)
  TopMetal2_10.sweep_along_vector((0mm, 0mm, TopMetal2_thickness))
  TopMetal2_11 [TopMetal2] = polyline(z=TopMetal2_lower_elevation, xy in mm: (-0.008, -0.044) (-0.004, -0.044) (-0.004, -0.023172) (-0.005172, -0.022) (-0.006828, -0.022) (-0.008, -0.023172) (-0.008, -0.044), closed, covered)
  TopMetal2_11.sweep_along_vector((0mm, 0mm, TopMetal2_thickness))
  TopMetal2_12 [TopMetal2] = polyline(z=TopMetal2_lower_elevation, xy in mm: (0.004, -0.044) (0.008, -0.044) (0.008, -0.036) (0.004, -0.036) (0.004, -0.044), closed, covered)
  TopMetal2_12.sweep_along_vector((0mm, 0mm, TopMetal2_thickness))
  TopMetal2_13 [TopMetal2] = polyline(z=TopMetal2_lower_elevation, xy in mm: (-0.008, -0.044) (-0.004, -0.044) (-0.004, -0.036) (-0.008, -0.036) (-0.008, -0.044), closed, covered)
  TopMetal2_13.sweep_along_vector((0mm, 0mm, TopMetal2_thickness))
  TopMetal1_1 [TopMetal1] = polyline(z=TopMetal1_lower_elevation, xy in mm: (0.002, -0.024) (-0.002, -0.024) (-0.002, -0.036) (0.002, -0.036) (0.002, -0.024), closed, covered)
  TopMetal1_1.sweep_along_vector((0mm, 0mm, TopMetal1_thickness))
  TopMetal1_2 [TopMetal1] = polyline(z=TopMetal1_lower_elevation, xy in mm: (0.005172, 0.022) (0.006828, 0.022) (0.008, 0.023172) (0.008, 0.044) (0.004, 0.044) (0.004, 0.023172) (0.005172, 0.022), closed, covered)
  TopMetal1_2.sweep_along_vector((0mm, 0mm, TopMetal1_thickness))
  TopMetal1_3 [TopMetal1] = polyline(z=TopMetal1_lower_elevation, xy in mm: (0.005172, 0.022) (0.020828, 0.022) (0.022, 0.023172) (0.022, 0.024828) (0.020828, 0.026) (0.005172, 0.026) (0.004, 0.024828) (0.004, 0.023172) (0.005172, 0.022), closed, covered)
  TopMetal1_3.sweep_along_vector((0mm, 0mm, TopMetal1_thickness))
  TopMetal1_4 [TopMetal1] = polyline(z=TopMetal1_lower_elevation, xy in mm: (0.023172, 0.018) (0.024828, 0.018) (0.026, 0.019172) (0.026, 0.020828) (0.020828, 0.026) (0.019172, 0.026) (0.018, 0.024828) (0.018, 0.023172) (0.023172, 0.018), closed, covered)
  TopMetal1_4.sweep_along_vector((0mm, 0mm, TopMetal1_thickness))
  TopMetal1_5 [TopMetal1] = polyline(z=TopMetal1_lower_elevation, xy in mm: (0.023172, -0.022) (0.024828, -0.022) (0.026, -0.020828) (0.026, 0.020828) (0.024828, 0.022) (0.023172, 0.022) (0.022, 0.020828) (0.022, -0.020828) (0.023172, -0.022), closed, covered)
  TopMetal1_5.sweep_along_vector((0mm, 0mm, TopMetal1_thickness))
  TopMetal1_6 [TopMetal1] = polyline(z=TopMetal1_lower_elevation, xy in mm: (0.019172, -0.026) (0.020828, -0.026) (0.026, -0.020828) (0.026, -0.019172) (0.024828, -0.018) (0.023172, -0.018) (0.018, -0.023172) (0.018, -0.024828) (0.019172, -0.026), closed, covered)
  TopMetal1_6.sweep_along_vector((0mm, 0mm, TopMetal1_thickness))
  TopMetal1_7 [TopMetal1] = polyline(z=TopMetal1_lower_elevation, xy in mm: (-0.020828, -0.026) (0.020828, -0.026) (0.022, -0.024828) (0.022, -0.023172) (0.020828, -0.022) (-0.020828, -0.022) (-0.022, -0.023172) (-0.022, -0.024828) (-0.020828, -0.026), closed, covered)
  TopMetal1_7.sweep_along_vector((0mm, 0mm, TopMetal1_thickness))
  TopMetal1_8 [TopMetal1] = polyline(z=TopMetal1_lower_elevation, xy in mm: (-0.020828, -0.026) (-0.019172, -0.026) (-0.018, -0.024828) (-0.018, -0.023172) (-0.023172, -0.018) (-0.024828, -0.018) (-0.026, -0.019172) (-0.026, -0.020828) (-0.020828, -0.026), closed, covered)
  TopMetal1_8.sweep_along_vector((0mm, 0mm, TopMetal1_thickness))
  TopMetal1_9 [TopMetal1] = polyline(z=TopMetal1_lower_elevation, xy in mm: (-0.024828, -0.022) (-0.023172, -0.022) (-0.022, -0.020828) (-0.022, 0.020828) (-0.023172, 0.022) (-0.024828, 0.022) (-0.026, 0.020828) (-0.026, -0.020828) (-0.024828, -0.022), closed, covered)
  TopMetal1_9.sweep_along_vector((0mm, 0mm, TopMetal1_thickness))
  TopMetal1_10 [TopMetal1] = polyline(z=TopMetal1_lower_elevation, xy in mm: (-0.024828, 0.018) (-0.023172, 0.018) (-0.018, 0.023172) (-0.018, 0.024828) (-0.019172, 0.026) (-0.020828, 0.026) (-0.026, 0.020828) (-0.026, 0.019172) (-0.024828, 0.018), closed, covered)
  TopMetal1_10.sweep_along_vector((0mm, 0mm, TopMetal1_thickness))
  TopMetal1_11 [TopMetal1] = polyline(z=TopMetal1_lower_elevation, xy in mm: (-0.020828, 0.022) (-0.005172, 0.022) (-0.004, 0.023172) (-0.004, 0.024828) (-0.005172, 0.026) (-0.020828, 0.026) (-0.022, 0.024828) (-0.022, 0.023172) (-0.020828, 0.022), closed, covered)
  TopMetal1_11.sweep_along_vector((0mm, 0mm, TopMetal1_thickness))
  TopMetal1_12 [TopMetal1] = polyline(z=TopMetal1_lower_elevation, xy in mm: (-0.006828, 0.022) (-0.005172, 0.022) (-0.004, 0.023172) (-0.004, 0.044) (-0.008, 0.044) (-0.008, 0.023172) (-0.006828, 0.022), closed, covered)
  TopMetal1_12.sweep_along_vector((0mm, 0mm, TopMetal1_thickness))
  TopMetal1_13 [TopMetal1] = polyline(z=TopMetal1_lower_elevation, xy in mm: (-0.0015, -0.036) (0.0015, -0.036) (0.0015, -0.032) (-0.0015, -0.032) (-0.0015, -0.036), closed, covered)
  TopMetal1_13.sweep_along_vector((0mm, 0mm, TopMetal1_thickness))
  TopMetal1_14 [TopMetal1] = polyline(z=TopMetal1_lower_elevation, xy in mm: (0.004, 0.036) (0.008, 0.036) (0.008, 0.044) (0.004, 0.044) (0.004, 0.036), closed, covered)
  TopMetal1_14.sweep_along_vector((0mm, 0mm, TopMetal1_thickness))
  TopMetal1_15 [TopMetal1] = polyline(z=TopMetal1_lower_elevation, xy in mm: (-0.008, 0.036) (-0.004, 0.036) (-0.004, 0.044) (-0.008, 0.044) (-0.008, 0.036), closed, covered)
  TopMetal1_15.sweep_along_vector((0mm, 0mm, TopMetal1_thickness))
  pa = rectangle(corner=(-8um, -44um, 289.33um), z_size=5.65um, x_size=4um)
  pb = rectangle(corner=(4um, -44um, 289.33um), z_size=5.65um, x_size=4um)
  pc = rectangle(corner=(-8um, 44um, 289.33um), z_size=0.85um, x_size=4um)
  pd = rectangle(corner=(4um, 44um, 289.33um), z_size=0.85um, x_size=4um)
  ct = rectangle(corner=(-1.5um, -36um, 289.33um), z_size=0.85um, x_size=3um)
boundaries and excitations:
  Rad1: Radiation Faces=Air.face(all 6)
  1: Lumped Port Objects=pa Modes{Mode1{IntLine{middle of pa.edge(z at corner) -> middle of pa.edge(z opposite corner)} CharImp=Zpi RenormImp=50ohm}} Impedance=50ohm
  2: Lumped Port Objects=pb Modes{Mode1{IntLine{middle of pb.edge(z at corner) -> middle of pb.edge(z opposite corner)} CharImp=Zpi RenormImp=50ohm}} Impedance=50ohm
  3: Lumped Port Objects=pc Modes{Mode1{IntLine{middle of pc.edge(z at corner) -> middle of pc.edge(z opposite corner)} CharImp=Zpi RenormImp=50ohm}} Impedance=50ohm
  4: Lumped Port Objects=pd Modes{Mode1{IntLine{middle of pd.edge(z at corner) -> middle of pd.edge(z opposite corner)} CharImp=Zpi RenormImp=50ohm}} Impedance=50ohm
  5: Lumped Port Objects=ct Modes{Mode1{IntLine{middle of ct.edge(z at corner) -> middle of ct.edge(z opposite corner)} CharImp=Zpi RenormImp=50ohm}} Impedance=50ohm
setups:
  Setup1: HfssDriven Frequency=140000000000Hz MaxDeltaS=0.02 MaximumPasses=20 MinimumPasses=2 MinimumConvergedPasses=2 PercentRefinement=30 BasisOrder=2 Target=0.6667 PortAccuracy=2
    sweep Sweep1: 0Hz to 180000000000Hz step 10000000000Hz; Type=Interpolating InterpTolerance=0.5 InterpMaxSolns=250 MinSolvedFreq=0.01GHz InterpUsePortImped=false PassivityErrorTolerance=0.0001
source amplitudes:
  1:1: 1W 0deg
  2:1, 3:1, 4:1, 5:1: 0W 0deg

design XTF5PR26 (HFSS, DrivenModal, model units mm)
options: Allow_Material_Override
variables:
  extent_x_pos = 1000mm
  extent_y_pos = 1000mm
  extent_x_size = -1000mm
  extent_y_size = -1000mm
  Activ_thickness = 0.0004mm
  Activ_lower_elevation = 0.28375mm
  extent_x_pos_1 = 1000mm
  extent_y_pos_1 = 1000mm
  extent_x_size_1 = -1000mm
  extent_y_size_1 = -1000mm
  Metal1_thickness = 0.00049mm
  Metal1_lower_elevation = 0.28479mm
  extent_x_pos_2 = 1000mm
  extent_y_pos_2 = 1000mm
  extent_x_size_2 = -1000mm
  extent_y_size_2 = -1000mm
  Metal2_thickness = 0.00049mm
  Metal2_lower_elevation = 0.28575mm
  extent_x_pos_3 = 1000mm
  extent_y_pos_3 = 1000mm
  extent_x_size_3 = -1000mm
  extent_y_size_3 = -1000mm
  Metal3_thickness = 0.00049mm
  Metal3_lower_elevation = 0.28678mm
  extent_x_pos_4 = -0.08mm
  extent_y_pos_4 = -0.046mm
  extent_x_size_4 = 0.16mm
  extent_y_size_4 = 0.092mm
  Metal4_thickness = 0.00049mm
  Metal4_lower_elevation = 0.28781mm
  extent_x_pos_5 = -0.08mm
  extent_y_pos_5 = -0.046mm
  extent_x_size_5 = 0.16mm
  extent_y_size_5 = 0.092mm
  Metal5_thickness = 0.00049mm
  Metal5_lower_elevation = 0.28884mm
  extent_x_pos_6 = -0.028mm
  extent_y_pos_6 = -0.046mm
  extent_x_size_6 = 0.056mm
  extent_y_size_6 = 0.074mm
  TopMetal2_thickness = 0.003mm
  TopMetal2_lower_elevation = 0.29552mm
  extent_x_pos_7 = -0.028mm
  extent_y_pos_7 = -0.038mm
  extent_x_size_7 = 0.056mm
  extent_y_size_7 = 0.084mm
  TopMetal1_thickness = 0.002mm
  TopMetal1_lower_elevation = 0.29072mm
  extent_x_pos_8 = 1000mm
  extent_y_pos_8 = 1000mm
  extent_x_size_8 = -1000mm
  extent_y_size_8 = -1000mm
  TopVia2_thickness = 0.0028mm
  TopVia2_lower_elevation = 0.29272mm
  extent_x_pos_9 = 1000mm
  extent_y_pos_9 = 1000mm
  extent_x_size_9 = -1000mm
  extent_y_size_9 = -1000mm
  TopVia1_thickness = 0.00139mm
  TopVia1_lower_elevation = 0.28933mm
  extent_x_pos_10 = 1000mm
  extent_y_pos_10 = 1000mm
  extent_x_size_10 = -1000mm
  extent_y_size_10 = -1000mm
  Vmim_thickness = 0.00066mm
  Vmim_lower_elevation = 0.29006mm
  extent_x_pos_11 = 1000mm
  extent_y_pos_11 = 1000mm
  extent_x_size_11 = -1000mm
  extent_y_size_11 = -1000mm
  MIM_thickness = 0.00066mm
  MIM_lower_elevation = 0.28987mm
  extent_x_pos_12 = 1000mm
  extent_y_pos_12 = 1000mm
  extent_x_size_12 = -1000mm
  extent_y_size_12 = -1000mm
  Via4_thickness = 0.00054mm
  Via4_lower_elevation = 0.2883mm
  extent_x_pos_13 = 1000mm
  extent_y_pos_13 = 1000mm
  extent_x_size_13 = -1000mm
  extent_y_size_13 = -1000mm
  Via3_thickness = 0.00054mm
  Via3_lower_elevation = 0.28727mm
  extent_x_pos_14 = 1000mm
  extent_y_pos_14 = 1000mm
  extent_x_size_14 = -1000mm
  extent_y_size_14 = -1000mm
  Via2_thickness = 0.00054mm
  Via2_lower_elevation = 0.28624mm
  extent_x_pos_15 = 1000mm
  extent_y_pos_15 = 1000mm
  extent_x_size_15 = -1000mm
  extent_y_size_15 = -1000mm
  Via1_thickness = 0.00047mm
  Via1_lower_elevation = 0.28528mm
  extent_x_pos_16 = 1000mm
  extent_y_pos_16 = 1000mm
  extent_x_size_16 = -1000mm
  extent_y_size_16 = -1000mm
  Cont_thickness = 0.00064mm
  Cont_lower_elevation = 0.28415mm
geometry:
  Substrate [ihp_SI] = box(corner=(-100um, -100um, 0um), size=(200um, 200um, 280um))
  EPI [ihp_EPI] = box(corner=(-100um, -100um, 280um), size=(200um, 200um, 3.75um))
  SBM1 [ihp_SIO2] = box(corner=(-100um, -100um, 283.75um), size=(200um, 200um, 1.04um))
  SAM1 [ihp_SIO2] = box(corner=(-100um, -100um, 284.79um), size=(200um, 200um, 0.96um))
  SAM2 [ihp_SIO2] = box(corner=(-100um, -100um, 285.75um), size=(200um, 200um, 1.03um))
  SAM3 [ihp_SIO2] = box(corner=(-100um, -100um, 286.78um), size=(200um, 200um, 1.03um))
  SAM4 [ihp_SIO2] = box(corner=(-100um, -100um, 287.81um), size=(200um, 200um, 1.03um))
  SAM5 [ihp_SIO2] = box(corner=(-100um, -100um, 288.84um), size=(200um, 200um, 0.49um))
  SMIM1 [ihp_MIMD] = box(corner=(-100um, -100um, 289.33um), size=(200um, 200um, 0.04um))
  SMIM2 [ihp_SIO2] = box(corner=(-100um, -100um, 289.37um), size=(200um, 200um, 0.81um))
  TM1 [ihp_SIO2] = box(corner=(-100um, -100um, 290.18um), size=(200um, 200um, 4.8um))
  TM2 [ihp_SIO2] = box(corner=(-100um, -100um, 294.98um), size=(200um, 200um, 4.5um))
  PSV [ihp_PSV] = box(corner=(-100um, -100um, 299.48um), size=(200um, 200um, 0.4um))
  Air [Air] = box(corner=(-200um, -200um, -100um), size=(400um, 400um, 1000um))
  Metal4_1 [Metal4] = polyline(z=Metal4_lower_elevation, xy in mm: (-0.038, -0.046) (0.038, -0.046) (0.038, -0.034) (-0.038, -0.034) (-0.038, -0.046), closed, covered)
  Metal4_1.sweep_along_vector((0mm, 0mm, Metal4_thickness))
  Metal4_2 [Metal4] = polyline(z=Metal4_lower_elevation, xy in mm: (-0.038, -0.046) (0.038, -0.046) (0.038, -0.034) (-0.038, -0.034) (-0.038, -0.046), closed, covered)
  Metal4_2.sweep_along_vector((0mm, 0mm, Metal4_thickness))
  Metal4_3 [Metal4] = polyline(z=Metal4_lower_elevation, xy in mm: (-0.038, 0.034) (0.038, 0.034) (0.038, 0.046) (-0.038, 0.046) (-0.038, 0.034), closed, covered)
  Metal4_3.sweep_along_vector((0mm, 0mm, Metal4_thickness))
  Metal4_4 [Metal4] = polyline(z=Metal4_lower_elevation, xy in mm: (-0.038, 0.034) (0.038, 0.034) (0.038, 0.046) (-0.038, 0.046) (-0.038, 0.034), closed, covered)
  Metal4_4.sweep_along_vector((0mm, 0mm, Metal4_thickness))
  Metal4_5 [Metal4] = polyline(z=Metal4_lower_elevation, xy in mm: (0.038, -0.046) (0.08, -0.046) (0.08, 0.046) (0.038, 0.046) (0.038, -0.046), closed, covered)
  Metal4_5.sweep_along_vector((0mm, 0mm, Metal4_thickness))
  Metal4_6 [Metal4] = polyline(z=Metal4_lower_elevation, xy in mm: (0.038, -0.046) (0.08, -0.046) (0.08, 0.046) (0.038, 0.046) (0.038, -0.046), closed, covered)
  Metal4_6.sweep_along_vector((0mm, 0mm, Metal4_thickness))
  Metal4_7 [Metal4] = polyline(z=Metal4_lower_elevation, xy in mm: (-0.08, -0.046) (-0.038, -0.046) (-0.038, 0.046) (-0.08, 0.046) (-0.08, -0.046), closed, covered)
  Metal4_7.sweep_along_vector((0mm, 0mm, Metal4_thickness))
  Metal4_8 [Metal4] = polyline(z=Metal4_lower_elevation, xy in mm: (-0.08, -0.046) (-0.038, -0.046) (-0.038, 0.046) (-0.08, 0.046) (-0.08, -0.046), closed, covered)
  Metal4_8.sweep_along_vector((0mm, 0mm, Metal4_thickness))
  Metal5_1 [Metal5] = polyline(z=Metal5_lower_elevation, xy in mm: (-0.038, -0.046) (0.038, -0.046) (0.038, -0.034) (-0.038, -0.034) (-0.038, -0.046), closed, covered)
  Metal5_1.sweep_along_vector((0mm, 0mm, Metal5_thickness))
  Metal5_2 [Metal5] = polyline(z=Metal5_lower_elevation, xy in mm: (-0.038, -0.046) (0.038, -0.046) (0.038, -0.034) (-0.038, -0.034) (-0.038, -0.046), closed, covered)
  Metal5_2.sweep_along_vector((0mm, 0mm, Metal5_thickness))
  Metal5_3 [Metal5] = polyline(z=Metal5_lower_elevation, xy in mm: (-0.038, 0.034) (0.038, 0.034) (0.038, 0.046) (-0.038, 0.046) (-0.038, 0.034), closed, covered)
  Metal5_3.sweep_along_vector((0mm, 0mm, Metal5_thickness))
  Metal5_4 [Metal5] = polyline(z=Metal5_lower_elevation, xy in mm: (-0.038, 0.034) (0.038, 0.034) (0.038, 0.046) (-0.038, 0.046) (-0.038, 0.034), closed, covered)
  Metal5_4.sweep_along_vector((0mm, 0mm, Metal5_thickness))
  Metal5_5 [Metal5] = polyline(z=Metal5_lower_elevation, xy in mm: (0.038, -0.046) (0.08, -0.046) (0.08, 0.046) (0.038, 0.046) (0.038, -0.046), closed, covered)
  Metal5_5.sweep_along_vector((0mm, 0mm, Metal5_thickness))
  Metal5_6 [Metal5] = polyline(z=Metal5_lower_elevation, xy in mm: (0.038, -0.046) (0.08, -0.046) (0.08, 0.046) (0.038, 0.046) (0.038, -0.046), closed, covered)
  Metal5_6.sweep_along_vector((0mm, 0mm, Metal5_thickness))
  Metal5_7 [Metal5] = polyline(z=Metal5_lower_elevation, xy in mm: (-0.08, -0.046) (-0.038, -0.046) (-0.038, 0.046) (-0.08, 0.046) (-0.08, -0.046), closed, covered)
  Metal5_7.sweep_along_vector((0mm, 0mm, Metal5_thickness))
  Metal5_8 [Metal5] = polyline(z=Metal5_lower_elevation, xy in mm: (-0.08, -0.046) (-0.038, -0.046) (-0.038, 0.046) (-0.08, 0.046) (-0.08, -0.046), closed, covered)
  Metal5_8.sweep_along_vector((0mm, 0mm, Metal5_thickness))
  TopMetal2_1 [TopMetal2] = polyline(z=TopMetal2_lower_elevation, xy in mm: (0.004, -0.046) (0.008, -0.046) (0.008, -0.025172) (0.006828, -0.024) (0.005172, -0.024) (0.004, -0.025172) (0.004, -0.046), closed, covered)
  TopMetal2_1.sweep_along_vector((0mm, 0mm, TopMetal2_thickness))
  TopMetal2_2 [TopMetal2] = polyline(z=TopMetal2_lower_elevation, xy in mm: (0.005172, -0.028) (0.022828, -0.028) (0.024, -0.026828) (0.024, -0.025172) (0.022828, -0.024) (0.005172, -0.024) (0.004, -0.025172) (0.004, -0.026828) (0.005172, -0.028), closed, covered)
  TopMetal2_2.sweep_along_vector((0mm, 0mm, TopMetal2_thickness))
  TopMetal2_3 [TopMetal2] = polyline(z=TopMetal2_lower_elevation, xy in mm: (0.021172, -0.028) (0.022828, -0.028) (0.028, -0.022828) (0.028, -0.021172) (0.026828, -0.02) (0.025172, -0.02) (0.02, -0.025172) (0.02, -0.026828) (0.021172, -0.028), closed, covered)
  TopMetal2_3.sweep_along_vector((0mm, 0mm, TopMetal2_thickness))
  TopMetal2_4 [TopMetal2] = polyline(z=TopMetal2_lower_elevation, xy in mm: (0.025172, -0.024) (0.026828, -0.024) (0.028, -0.022828) (0.028, 0.022828) (0.026828, 0.024) (0.025172, 0.024) (0.024, 0.022828) (0.024, -0.022828) (0.025172, -0.024), closed, covered)
  TopMetal2_4.sweep_along_vector((0mm, 0mm, TopMetal2_thickness))
  TopMetal2_5 [TopMetal2] = polyline(z=TopMetal2_lower_elevation, xy in mm: (0.025172, 0.02) (0.026828, 0.02) (0.028, 0.021172) (0.028, 0.022828) (0.022828, 0.028) (0.021172, 0.028) (0.02, 0.026828) (0.02, 0.025172) (0.025172, 0.02), closed, covered)
  TopMetal2_5.sweep_along_vector((0mm, 0mm, TopMetal2_thickness))
  TopMetal2_6 [TopMetal2] = polyline(z=TopMetal2_lower_elevation, xy in mm: (-0.022828, 0.024) (0.022828, 0.024) (0.024, 0.025172) (0.024, 0.026828) (0.022828, 0.028) (-0.022828, 0.028) (-0.024, 0.026828) (-0.024, 0.025172) (-0.022828, 0.024), closed, covered)
  TopMetal2_6.sweep_along_vector((0mm, 0mm, TopMetal2_thickness))
  TopMetal2_7 [TopMetal2] = polyline(z=TopMetal2_lower_elevation, xy in mm: (-0.026828, 0.02) (-0.025172, 0.02) (-0.02, 0.025172) (-0.02, 0.026828) (-0.021172, 0.028) (-0.022828, 0.028) (-0.028, 0.022828) (-0.028, 0.021172) (-0.026828, 0.02), closed, covered)
  TopMetal2_7.sweep_along_vector((0mm, 0mm, TopMetal2_thickness))
  TopMetal2_8 [TopMetal2] = polyline(z=TopMetal2_lower_elevation, xy in mm: (-0.026828, -0.024) (-0.025172, -0.024) (-0.024, -0.022828) (-0.024, 0.022828) (-0.025172, 0.024) (-0.026828, 0.024) (-0.028, 0.022828) (-0.028, -0.022828) (-0.026828, -0.024), closed, covered)
  TopMetal2_8.sweep_along_vector((0mm, 0mm, TopMetal2_thickness))
  TopMetal2_9 [TopMetal2] = polyline(z=TopMetal2_lower_elevation, xy in mm: (-0.022828, -0.028) (-0.021172, -0.028) (-0.02, -0.026828) (-0.02, -0.025172) (-0.025172, -0.02) (-0.026828, -0.02) (-0.028, -0.021172) (-0.028, -0.022828) (-0.022828, -0.028), closed, covered)
  TopMetal2_9.sweep_along_vector((0mm, 0mm, TopMetal2_thickness))
  TopMetal2_10 [TopMetal2] = polyline(z=TopMetal2_lower_elevation, xy in mm: (-0.022828, -0.028) (-0.005172, -0.028) (-0.004, -0.026828) (-0.004, -0.025172) (-0.005172, -0.024) (-0.022828, -0.024) (-0.024, -0.025172) (-0.024, -0.026828) (-0.022828, -0.028), closed, covered)
  TopMetal2_10.sweep_along_vector((0mm, 0mm, TopMetal2_thickness))
  TopMetal2_11 [TopMetal2] = polyline(z=TopMetal2_lower_elevation, xy in mm: (-0.008, -0.046) (-0.004, -0.046) (-0.004, -0.025172) (-0.005172, -0.024) (-0.006828, -0.024) (-0.008, -0.025172) (-0.008, -0.046), closed, covered)
  TopMetal2_11.sweep_along_vector((0mm, 0mm, TopMetal2_thickness))
  TopMetal2_12 [TopMetal2] = polyline(z=TopMetal2_lower_elevation, xy in mm: (0.004, -0.046) (0.008, -0.046) (0.008, -0.038) (0.004, -0.038) (0.004, -0.046), closed, covered)
  TopMetal2_12.sweep_along_vector((0mm, 0mm, TopMetal2_thickness))
  TopMetal2_13 [TopMetal2] = polyline(z=TopMetal2_lower_elevation, xy in mm: (-0.008, -0.046) (-0.004, -0.046) (-0.004, -0.038) (-0.008, -0.038) (-0.008, -0.046), closed, covered)
  TopMetal2_13.sweep_along_vector((0mm, 0mm, TopMetal2_thickness))
  TopMetal1_1 [TopMetal1] = polyline(z=TopMetal1_lower_elevation, xy in mm: (0.002, -0.026) (-0.002, -0.026) (-0.002, -0.038) (0.002, -0.038) (0.002, -0.026), closed, covered)
  TopMetal1_1.sweep_along_vector((0mm, 0mm, TopMetal1_thickness))
  TopMetal1_2 [TopMetal1] = polyline(z=TopMetal1_lower_elevation, xy in mm: (0.005172, 0.024) (0.006828, 0.024) (0.008, 0.025172) (0.008, 0.046) (0.004, 0.046) (0.004, 0.025172) (0.005172, 0.024), closed, covered)
  TopMetal1_2.sweep_along_vector((0mm, 0mm, TopMetal1_thickness))
  TopMetal1_3 [TopMetal1] = polyline(z=TopMetal1_lower_elevation, xy in mm: (0.005172, 0.024) (0.022828, 0.024) (0.024, 0.025172) (0.024, 0.026828) (0.022828, 0.028) (0.005172, 0.028) (0.004, 0.026828) (0.004, 0.025172) (0.005172, 0.024), closed, covered)
  TopMetal1_3.sweep_along_vector((0mm, 0mm, TopMetal1_thickness))
  TopMetal1_4 [TopMetal1] = polyline(z=TopMetal1_lower_elevation, xy in mm: (0.025172, 0.02) (0.026828, 0.02) (0.028, 0.021172) (0.028, 0.022828) (0.022828, 0.028) (0.021172, 0.028) (0.02, 0.026828) (0.02, 0.025172) (0.025172, 0.02), closed, covered)
  TopMetal1_4.sweep_along_vector((0mm, 0mm, TopMetal1_thickness))
  TopMetal1_5 [TopMetal1] = polyline(z=TopMetal1_lower_elevation, xy in mm: (0.025172, -0.024) (0.026828, -0.024) (0.028, -0.022828) (0.028, 0.022828) (0.026828, 0.024) (0.025172, 0.024) (0.024, 0.022828) (0.024, -0.022828) (0.025172, -0.024), closed, covered)
  TopMetal1_5.sweep_along_vector((0mm, 0mm, TopMetal1_thickness))
  TopMetal1_6 [TopMetal1] = polyline(z=TopMetal1_lower_elevation, xy in mm: (0.021172, -0.028) (0.022828, -0.028) (0.028, -0.022828) (0.028, -0.021172) (0.026828, -0.02) (0.025172, -0.02) (0.02, -0.025172) (0.02, -0.026828) (0.021172, -0.028), closed, covered)
  TopMetal1_6.sweep_along_vector((0mm, 0mm, TopMetal1_thickness))
  TopMetal1_7 [TopMetal1] = polyline(z=TopMetal1_lower_elevation, xy in mm: (-0.022828, -0.028) (0.022828, -0.028) (0.024, -0.026828) (0.024, -0.025172) (0.022828, -0.024) (-0.022828, -0.024) (-0.024, -0.025172) (-0.024, -0.026828) (-0.022828, -0.028), closed, covered)
  TopMetal1_7.sweep_along_vector((0mm, 0mm, TopMetal1_thickness))
  TopMetal1_8 [TopMetal1] = polyline(z=TopMetal1_lower_elevation, xy in mm: (-0.022828, -0.028) (-0.021172, -0.028) (-0.02, -0.026828) (-0.02, -0.025172) (-0.025172, -0.02) (-0.026828, -0.02) (-0.028, -0.021172) (-0.028, -0.022828) (-0.022828, -0.028), closed, covered)
  TopMetal1_8.sweep_along_vector((0mm, 0mm, TopMetal1_thickness))
  TopMetal1_9 [TopMetal1] = polyline(z=TopMetal1_lower_elevation, xy in mm: (-0.026828, -0.024) (-0.025172, -0.024) (-0.024, -0.022828) (-0.024, 0.022828) (-0.025172, 0.024) (-0.026828, 0.024) (-0.028, 0.022828) (-0.028, -0.022828) (-0.026828, -0.024), closed, covered)
  TopMetal1_9.sweep_along_vector((0mm, 0mm, TopMetal1_thickness))
  TopMetal1_10 [TopMetal1] = polyline(z=TopMetal1_lower_elevation, xy in mm: (-0.026828, 0.02) (-0.025172, 0.02) (-0.02, 0.025172) (-0.02, 0.026828) (-0.021172, 0.028) (-0.022828, 0.028) (-0.028, 0.022828) (-0.028, 0.021172) (-0.026828, 0.02), closed, covered)
  TopMetal1_10.sweep_along_vector((0mm, 0mm, TopMetal1_thickness))
  TopMetal1_11 [TopMetal1] = polyline(z=TopMetal1_lower_elevation, xy in mm: (-0.022828, 0.024) (-0.005172, 0.024) (-0.004, 0.025172) (-0.004, 0.026828) (-0.005172, 0.028) (-0.022828, 0.028) (-0.024, 0.026828) (-0.024, 0.025172) (-0.022828, 0.024), closed, covered)
  TopMetal1_11.sweep_along_vector((0mm, 0mm, TopMetal1_thickness))
  TopMetal1_12 [TopMetal1] = polyline(z=TopMetal1_lower_elevation, xy in mm: (-0.006828, 0.024) (-0.005172, 0.024) (-0.004, 0.025172) (-0.004, 0.046) (-0.008, 0.046) (-0.008, 0.025172) (-0.006828, 0.024), closed, covered)
  TopMetal1_12.sweep_along_vector((0mm, 0mm, TopMetal1_thickness))
  TopMetal1_13 [TopMetal1] = polyline(z=TopMetal1_lower_elevation, xy in mm: (-0.0015, -0.038) (0.0015, -0.038) (0.0015, -0.034) (-0.0015, -0.034) (-0.0015, -0.038), closed, covered)
  TopMetal1_13.sweep_along_vector((0mm, 0mm, TopMetal1_thickness))
  TopMetal1_14 [TopMetal1] = polyline(z=TopMetal1_lower_elevation, xy in mm: (0.004, 0.038) (0.008, 0.038) (0.008, 0.046) (0.004, 0.046) (0.004, 0.038), closed, covered)
  TopMetal1_14.sweep_along_vector((0mm, 0mm, TopMetal1_thickness))
  TopMetal1_15 [TopMetal1] = polyline(z=TopMetal1_lower_elevation, xy in mm: (-0.008, 0.038) (-0.004, 0.038) (-0.004, 0.046) (-0.008, 0.046) (-0.008, 0.038), closed, covered)
  TopMetal1_15.sweep_along_vector((0mm, 0mm, TopMetal1_thickness))
  pa = rectangle(corner=(-8um, -46um, 289.33um), z_size=5.65um, x_size=4um)
  pb = rectangle(corner=(4um, -46um, 289.33um), z_size=5.65um, x_size=4um)
  pc = rectangle(corner=(-8um, 46um, 289.33um), z_size=0.85um, x_size=4um)
  pd = rectangle(corner=(4um, 46um, 289.33um), z_size=0.85um, x_size=4um)
  ct = rectangle(corner=(-1.5um, -38um, 289.33um), z_size=0.85um, x_size=3um)
boundaries and excitations:
  Rad1: Radiation Faces=Air.face(all 6)
  1: Lumped Port Objects=pa Modes{Mode1{IntLine{middle of pa.edge(z at corner) -> middle of pa.edge(z opposite corner)} CharImp=Zpi RenormImp=50ohm}} Impedance=50ohm
  2: Lumped Port Objects=pb Modes{Mode1{IntLine{middle of pb.edge(z at corner) -> middle of pb.edge(z opposite corner)} CharImp=Zpi RenormImp=50ohm}} Impedance=50ohm
  3: Lumped Port Objects=pc Modes{Mode1{IntLine{middle of pc.edge(z at corner) -> middle of pc.edge(z opposite corner)} CharImp=Zpi RenormImp=50ohm}} Impedance=50ohm
  4: Lumped Port Objects=pd Modes{Mode1{IntLine{middle of pd.edge(z at corner) -> middle of pd.edge(z opposite corner)} CharImp=Zpi RenormImp=50ohm}} Impedance=50ohm
  5: Lumped Port Objects=ct Modes{Mode1{IntLine{middle of ct.edge(z at corner) -> middle of ct.edge(z opposite corner)} CharImp=Zpi RenormImp=50ohm}} Impedance=50ohm
setups:
  Setup1: HfssDriven Frequency=140000000000Hz MaxDeltaS=0.02 MaximumPasses=20 MinimumPasses=2 MinimumConvergedPasses=2 PercentRefinement=30 BasisOrder=2 Target=0.6667 PortAccuracy=2
    sweep Sweep1: 0Hz to 180000000000Hz step 10000000000Hz; Type=Interpolating InterpTolerance=0.5 InterpMaxSolns=250 MinSolvedFreq=0.01GHz InterpUsePortImped=false PassivityErrorTolerance=0.0001
source amplitudes:
  1:1: 1W 0deg
  2:1, 3:1, 4:1, 5:1: 0W 0deg

design XTF5PR28 (HFSS, DrivenModal, model units mm)
options: Allow_Material_Override
variables:
  extent_x_pos = 1000mm
  extent_y_pos = 1000mm
  extent_x_size = -1000mm
  extent_y_size = -1000mm
  Activ_thickness = 0.0004mm
  Activ_lower_elevation = 0.28375mm
  extent_x_pos_1 = 1000mm
  extent_y_pos_1 = 1000mm
  extent_x_size_1 = -1000mm
  extent_y_size_1 = -1000mm
  Metal1_thickness = 0.00049mm
  Metal1_lower_elevation = 0.28479mm
  extent_x_pos_2 = 1000mm
  extent_y_pos_2 = 1000mm
  extent_x_size_2 = -1000mm
  extent_y_size_2 = -1000mm
  Metal2_thickness = 0.00049mm
  Metal2_lower_elevation = 0.28575mm
  extent_x_pos_3 = 1000mm
  extent_y_pos_3 = 1000mm
  extent_x_size_3 = -1000mm
  extent_y_size_3 = -1000mm
  Metal3_thickness = 0.00049mm
  Metal3_lower_elevation = 0.28678mm
  extent_x_pos_4 = -0.08mm
  extent_y_pos_4 = -0.048mm
  extent_x_size_4 = 0.16mm
  extent_y_size_4 = 0.096mm
  Metal4_thickness = 0.00049mm
  Metal4_lower_elevation = 0.28781mm
  extent_x_pos_5 = -0.08mm
  extent_y_pos_5 = -0.048mm
  extent_x_size_5 = 0.16mm
  extent_y_size_5 = 0.096mm
  Metal5_thickness = 0.00049mm
  Metal5_lower_elevation = 0.28884mm
  extent_x_pos_6 = -0.03mm
  extent_y_pos_6 = -0.048mm
  extent_x_size_6 = 0.06mm
  extent_y_size_6 = 0.078mm
  TopMetal2_thickness = 0.003mm
  TopMetal2_lower_elevation = 0.29552mm
  extent_x_pos_7 = -0.03mm
  extent_y_pos_7 = -0.04mm
  extent_x_size_7 = 0.06mm
  extent_y_size_7 = 0.088mm
  TopMetal1_thickness = 0.002mm
  TopMetal1_lower_elevation = 0.29072mm
  extent_x_pos_8 = 1000mm
  extent_y_pos_8 = 1000mm
  extent_x_size_8 = -1000mm
  extent_y_size_8 = -1000mm
  TopVia2_thickness = 0.0028mm
  TopVia2_lower_elevation = 0.29272mm
  extent_x_pos_9 = 1000mm
  extent_y_pos_9 = 1000mm
  extent_x_size_9 = -1000mm
  extent_y_size_9 = -1000mm
  TopVia1_thickness = 0.00139mm
  TopVia1_lower_elevation = 0.28933mm
  extent_x_pos_10 = 1000mm
  extent_y_pos_10 = 1000mm
  extent_x_size_10 = -1000mm
  extent_y_size_10 = -1000mm
  Vmim_thickness = 0.00066mm
  Vmim_lower_elevation = 0.29006mm
  extent_x_pos_11 = 1000mm
  extent_y_pos_11 = 1000mm
  extent_x_size_11 = -1000mm
  extent_y_size_11 = -1000mm
  MIM_thickness = 0.00066mm
  MIM_lower_elevation = 0.28987mm
  extent_x_pos_12 = 1000mm
  extent_y_pos_12 = 1000mm
  extent_x_size_12 = -1000mm
  extent_y_size_12 = -1000mm
  Via4_thickness = 0.00054mm
  Via4_lower_elevation = 0.2883mm
  extent_x_pos_13 = 1000mm
  extent_y_pos_13 = 1000mm
  extent_x_size_13 = -1000mm
  extent_y_size_13 = -1000mm
  Via3_thickness = 0.00054mm
  Via3_lower_elevation = 0.28727mm
  extent_x_pos_14 = 1000mm
  extent_y_pos_14 = 1000mm
  extent_x_size_14 = -1000mm
  extent_y_size_14 = -1000mm
  Via2_thickness = 0.00054mm
  Via2_lower_elevation = 0.28624mm
  extent_x_pos_15 = 1000mm
  extent_y_pos_15 = 1000mm
  extent_x_size_15 = -1000mm
  extent_y_size_15 = -1000mm
  Via1_thickness = 0.00047mm
  Via1_lower_elevation = 0.28528mm
  extent_x_pos_16 = 1000mm
  extent_y_pos_16 = 1000mm
  extent_x_size_16 = -1000mm
  extent_y_size_16 = -1000mm
  Cont_thickness = 0.00064mm
  Cont_lower_elevation = 0.28415mm
geometry:
  Substrate [ihp_SI] = box(corner=(-100um, -100um, 0um), size=(200um, 200um, 280um))
  EPI [ihp_EPI] = box(corner=(-100um, -100um, 280um), size=(200um, 200um, 3.75um))
  SBM1 [ihp_SIO2] = box(corner=(-100um, -100um, 283.75um), size=(200um, 200um, 1.04um))
  SAM1 [ihp_SIO2] = box(corner=(-100um, -100um, 284.79um), size=(200um, 200um, 0.96um))
  SAM2 [ihp_SIO2] = box(corner=(-100um, -100um, 285.75um), size=(200um, 200um, 1.03um))
  SAM3 [ihp_SIO2] = box(corner=(-100um, -100um, 286.78um), size=(200um, 200um, 1.03um))
  SAM4 [ihp_SIO2] = box(corner=(-100um, -100um, 287.81um), size=(200um, 200um, 1.03um))
  SAM5 [ihp_SIO2] = box(corner=(-100um, -100um, 288.84um), size=(200um, 200um, 0.49um))
  SMIM1 [ihp_MIMD] = box(corner=(-100um, -100um, 289.33um), size=(200um, 200um, 0.04um))
  SMIM2 [ihp_SIO2] = box(corner=(-100um, -100um, 289.37um), size=(200um, 200um, 0.81um))
  TM1 [ihp_SIO2] = box(corner=(-100um, -100um, 290.18um), size=(200um, 200um, 4.8um))
  TM2 [ihp_SIO2] = box(corner=(-100um, -100um, 294.98um), size=(200um, 200um, 4.5um))
  PSV [ihp_PSV] = box(corner=(-100um, -100um, 299.48um), size=(200um, 200um, 0.4um))
  Air [Air] = box(corner=(-200um, -200um, -100um), size=(400um, 400um, 1000um))
  Metal4_1 [Metal4] = polyline(z=Metal4_lower_elevation, xy in mm: (-0.04, -0.048) (0.04, -0.048) (0.04, -0.036) (-0.04, -0.036) (-0.04, -0.048), closed, covered)
  Metal4_1.sweep_along_vector((0mm, 0mm, Metal4_thickness))
  Metal4_2 [Metal4] = polyline(z=Metal4_lower_elevation, xy in mm: (-0.04, -0.048) (0.04, -0.048) (0.04, -0.036) (-0.04, -0.036) (-0.04, -0.048), closed, covered)
  Metal4_2.sweep_along_vector((0mm, 0mm, Metal4_thickness))
  Metal4_3 [Metal4] = polyline(z=Metal4_lower_elevation, xy in mm: (-0.04, 0.036) (0.04, 0.036) (0.04, 0.048) (-0.04, 0.048) (-0.04, 0.036), closed, covered)
  Metal4_3.sweep_along_vector((0mm, 0mm, Metal4_thickness))
  Metal4_4 [Metal4] = polyline(z=Metal4_lower_elevation, xy in mm: (-0.04, 0.036) (0.04, 0.036) (0.04, 0.048) (-0.04, 0.048) (-0.04, 0.036), closed, covered)
  Metal4_4.sweep_along_vector((0mm, 0mm, Metal4_thickness))
  Metal4_5 [Metal4] = polyline(z=Metal4_lower_elevation, xy in mm: (0.04, -0.048) (0.08, -0.048) (0.08, 0.048) (0.04, 0.048) (0.04, -0.048), closed, covered)
  Metal4_5.sweep_along_vector((0mm, 0mm, Metal4_thickness))
  Metal4_6 [Metal4] = polyline(z=Metal4_lower_elevation, xy in mm: (0.04, -0.048) (0.08, -0.048) (0.08, 0.048) (0.04, 0.048) (0.04, -0.048), closed, covered)
  Metal4_6.sweep_along_vector((0mm, 0mm, Metal4_thickness))
  Metal4_7 [Metal4] = polyline(z=Metal4_lower_elevation, xy in mm: (-0.08, -0.048) (-0.04, -0.048) (-0.04, 0.048) (-0.08, 0.048) (-0.08, -0.048), closed, covered)
  Metal4_7.sweep_along_vector((0mm, 0mm, Metal4_thickness))
  Metal4_8 [Metal4] = polyline(z=Metal4_lower_elevation, xy in mm: (-0.08, -0.048) (-0.04, -0.048) (-0.04, 0.048) (-0.08, 0.048) (-0.08, -0.048), closed, covered)
  Metal4_8.sweep_along_vector((0mm, 0mm, Metal4_thickness))
  Metal5_1 [Metal5] = polyline(z=Metal5_lower_elevation, xy in mm: (-0.04, -0.048) (0.04, -0.048) (0.04, -0.036) (-0.04, -0.036) (-0.04, -0.048), closed, covered)
  Metal5_1.sweep_along_vector((0mm, 0mm, Metal5_thickness))
  Metal5_2 [Metal5] = polyline(z=Metal5_lower_elevation, xy in mm: (-0.04, -0.048) (0.04, -0.048) (0.04, -0.036) (-0.04, -0.036) (-0.04, -0.048), closed, covered)
  Metal5_2.sweep_along_vector((0mm, 0mm, Metal5_thickness))
  Metal5_3 [Metal5] = polyline(z=Metal5_lower_elevation, xy in mm: (-0.04, 0.036) (0.04, 0.036) (0.04, 0.048) (-0.04, 0.048) (-0.04, 0.036), closed, covered)
  Metal5_3.sweep_along_vector((0mm, 0mm, Metal5_thickness))
  Metal5_4 [Metal5] = polyline(z=Metal5_lower_elevation, xy in mm: (-0.04, 0.036) (0.04, 0.036) (0.04, 0.048) (-0.04, 0.048) (-0.04, 0.036), closed, covered)
  Metal5_4.sweep_along_vector((0mm, 0mm, Metal5_thickness))
  Metal5_5 [Metal5] = polyline(z=Metal5_lower_elevation, xy in mm: (0.04, -0.048) (0.08, -0.048) (0.08, 0.048) (0.04, 0.048) (0.04, -0.048), closed, covered)
  Metal5_5.sweep_along_vector((0mm, 0mm, Metal5_thickness))
  Metal5_6 [Metal5] = polyline(z=Metal5_lower_elevation, xy in mm: (0.04, -0.048) (0.08, -0.048) (0.08, 0.048) (0.04, 0.048) (0.04, -0.048), closed, covered)
  Metal5_6.sweep_along_vector((0mm, 0mm, Metal5_thickness))
  Metal5_7 [Metal5] = polyline(z=Metal5_lower_elevation, xy in mm: (-0.08, -0.048) (-0.04, -0.048) (-0.04, 0.048) (-0.08, 0.048) (-0.08, -0.048), closed, covered)
  Metal5_7.sweep_along_vector((0mm, 0mm, Metal5_thickness))
  Metal5_8 [Metal5] = polyline(z=Metal5_lower_elevation, xy in mm: (-0.08, -0.048) (-0.04, -0.048) (-0.04, 0.048) (-0.08, 0.048) (-0.08, -0.048), closed, covered)
  Metal5_8.sweep_along_vector((0mm, 0mm, Metal5_thickness))
  TopMetal2_1 [TopMetal2] = polyline(z=TopMetal2_lower_elevation, xy in mm: (0.004, -0.048) (0.008, -0.048) (0.008, -0.027172) (0.006828, -0.026) (0.005172, -0.026) (0.004, -0.027172) (0.004, -0.048), closed, covered)
  TopMetal2_1.sweep_along_vector((0mm, 0mm, TopMetal2_thickness))
  TopMetal2_2 [TopMetal2] = polyline(z=TopMetal2_lower_elevation, xy in mm: (0.005172, -0.03) (0.024828, -0.03) (0.026, -0.028828) (0.026, -0.027172) (0.024828, -0.026) (0.005172, -0.026) (0.004, -0.027172) (0.004, -0.028828) (0.005172, -0.03), closed, covered)
  TopMetal2_2.sweep_along_vector((0mm, 0mm, TopMetal2_thickness))
  TopMetal2_3 [TopMetal2] = polyline(z=TopMetal2_lower_elevation, xy in mm: (0.023172, -0.03) (0.024828, -0.03) (0.03, -0.024828) (0.03, -0.023172) (0.028828, -0.022) (0.027172, -0.022) (0.022, -0.027172) (0.022, -0.028828) (0.023172, -0.03), closed, covered)
  TopMetal2_3.sweep_along_vector((0mm, 0mm, TopMetal2_thickness))
  TopMetal2_4 [TopMetal2] = polyline(z=TopMetal2_lower_elevation, xy in mm: (0.027172, -0.026) (0.028828, -0.026) (0.03, -0.024828) (0.03, 0.024828) (0.028828, 0.026) (0.027172, 0.026) (0.026, 0.024828) (0.026, -0.024828) (0.027172, -0.026), closed, covered)
  TopMetal2_4.sweep_along_vector((0mm, 0mm, TopMetal2_thickness))
  TopMetal2_5 [TopMetal2] = polyline(z=TopMetal2_lower_elevation, xy in mm: (0.027172, 0.022) (0.028828, 0.022) (0.03, 0.023172) (0.03, 0.024828) (0.024828, 0.03) (0.023172, 0.03) (0.022, 0.028828) (0.022, 0.027172) (0.027172, 0.022), closed, covered)
  TopMetal2_5.sweep_along_vector((0mm, 0mm, TopMetal2_thickness))
  TopMetal2_6 [TopMetal2] = polyline(z=TopMetal2_lower_elevation, xy in mm: (-0.024828, 0.026) (0.024828, 0.026) (0.026, 0.027172) (0.026, 0.028828) (0.024828, 0.03) (-0.024828, 0.03) (-0.026, 0.028828) (-0.026, 0.027172) (-0.024828, 0.026), closed, covered)
  TopMetal2_6.sweep_along_vector((0mm, 0mm, TopMetal2_thickness))
  TopMetal2_7 [TopMetal2] = polyline(z=TopMetal2_lower_elevation, xy in mm: (-0.028828, 0.022) (-0.027172, 0.022) (-0.022, 0.027172) (-0.022, 0.028828) (-0.023172, 0.03) (-0.024828, 0.03) (-0.03, 0.024828) (-0.03, 0.023172) (-0.028828, 0.022), closed, covered)
  TopMetal2_7.sweep_along_vector((0mm, 0mm, TopMetal2_thickness))
  TopMetal2_8 [TopMetal2] = polyline(z=TopMetal2_lower_elevation, xy in mm: (-0.028828, -0.026) (-0.027172, -0.026) (-0.026, -0.024828) (-0.026, 0.024828) (-0.027172, 0.026) (-0.028828, 0.026) (-0.03, 0.024828) (-0.03, -0.024828) (-0.028828, -0.026), closed, covered)
  TopMetal2_8.sweep_along_vector((0mm, 0mm, TopMetal2_thickness))
  TopMetal2_9 [TopMetal2] = polyline(z=TopMetal2_lower_elevation, xy in mm: (-0.024828, -0.03) (-0.023172, -0.03) (-0.022, -0.028828) (-0.022, -0.027172) (-0.027172, -0.022) (-0.028828, -0.022) (-0.03, -0.023172) (-0.03, -0.024828) (-0.024828, -0.03), closed, covered)
  TopMetal2_9.sweep_along_vector((0mm, 0mm, TopMetal2_thickness))
  TopMetal2_10 [TopMetal2] = polyline(z=TopMetal2_lower_elevation, xy in mm: (-0.024828, -0.03) (-0.005172, -0.03) (-0.004, -0.028828) (-0.004, -0.027172) (-0.005172, -0.026) (-0.024828, -0.026) (-0.026, -0.027172) (-0.026, -0.028828) (-0.024828, -0.03), closed, covered)
  TopMetal2_10.sweep_along_vector((0mm, 0mm, TopMetal2_thickness))
  TopMetal2_11 [TopMetal2] = polyline(z=TopMetal2_lower_elevation, xy in mm: (-0.008, -0.048) (-0.004, -0.048) (-0.004, -0.027172) (-0.005172, -0.026) (-0.006828, -0.026) (-0.008, -0.027172) (-0.008, -0.048), closed, covered)
  TopMetal2_11.sweep_along_vector((0mm, 0mm, TopMetal2_thickness))
  TopMetal2_12 [TopMetal2] = polyline(z=TopMetal2_lower_elevation, xy in mm: (0.004, -0.048) (0.008, -0.048) (0.008, -0.04) (0.004, -0.04) (0.004, -0.048), closed, covered)
  TopMetal2_12.sweep_along_vector((0mm, 0mm, TopMetal2_thickness))
  TopMetal2_13 [TopMetal2] = polyline(z=TopMetal2_lower_elevation, xy in mm: (-0.008, -0.048) (-0.004, -0.048) (-0.004, -0.04) (-0.008, -0.04) (-0.008, -0.048), closed, covered)
  TopMetal2_13.sweep_along_vector((0mm, 0mm, TopMetal2_thickness))
  TopMetal1_1 [TopMetal1] = polyline(z=TopMetal1_lower_elevation, xy in mm: (0.002, -0.028) (-0.002, -0.028) (-0.002, -0.04) (0.002, -0.04) (0.002, -0.028), closed, covered)
  TopMetal1_1.sweep_along_vector((0mm, 0mm, TopMetal1_thickness))
  TopMetal1_2 [TopMetal1] = polyline(z=TopMetal1_lower_elevation, xy in mm: (0.005172, 0.026) (0.006828, 0.026) (0.008, 0.027172) (0.008, 0.048) (0.004, 0.048) (0.004, 0.027172) (0.005172, 0.026), closed, covered)
  TopMetal1_2.sweep_along_vector((0mm, 0mm, TopMetal1_thickness))
  TopMetal1_3 [TopMetal1] = polyline(z=TopMetal1_lower_elevation, xy in mm: (0.005172, 0.026) (0.024828, 0.026) (0.026, 0.027172) (0.026, 0.028828) (0.024828, 0.03) (0.005172, 0.03) (0.004, 0.028828) (0.004, 0.027172) (0.005172, 0.026), closed, covered)
  TopMetal1_3.sweep_along_vector((0mm, 0mm, TopMetal1_thickness))
  TopMetal1_4 [TopMetal1] = polyline(z=TopMetal1_lower_elevation, xy in mm: (0.027172, 0.022) (0.028828, 0.022) (0.03, 0.023172) (0.03, 0.024828) (0.024828, 0.03) (0.023172, 0.03) (0.022, 0.028828) (0.022, 0.027172) (0.027172, 0.022), closed, covered)
  TopMetal1_4.sweep_along_vector((0mm, 0mm, TopMetal1_thickness))
  TopMetal1_5 [TopMetal1] = polyline(z=TopMetal1_lower_elevation, xy in mm: (0.027172, -0.026) (0.028828, -0.026) (0.03, -0.024828) (0.03, 0.024828) (0.028828, 0.026) (0.027172, 0.026) (0.026, 0.024828) (0.026, -0.024828) (0.027172, -0.026), closed, covered)
  TopMetal1_5.sweep_along_vector((0mm, 0mm, TopMetal1_thickness))
  TopMetal1_6 [TopMetal1] = polyline(z=TopMetal1_lower_elevation, xy in mm: (0.023172, -0.03) (0.024828, -0.03) (0.03, -0.024828) (0.03, -0.023172) (0.028828, -0.022) (0.027172, -0.022) (0.022, -0.027172) (0.022, -0.028828) (0.023172, -0.03), closed, covered)
  TopMetal1_6.sweep_along_vector((0mm, 0mm, TopMetal1_thickness))
  TopMetal1_7 [TopMetal1] = polyline(z=TopMetal1_lower_elevation, xy in mm: (-0.024828, -0.03) (0.024828, -0.03) (0.026, -0.028828) (0.026, -0.027172) (0.024828, -0.026) (-0.024828, -0.026) (-0.026, -0.027172) (-0.026, -0.028828) (-0.024828, -0.03), closed, covered)
  TopMetal1_7.sweep_along_vector((0mm, 0mm, TopMetal1_thickness))
  TopMetal1_8 [TopMetal1] = polyline(z=TopMetal1_lower_elevation, xy in mm: (-0.024828, -0.03) (-0.023172, -0.03) (-0.022, -0.028828) (-0.022, -0.027172) (-0.027172, -0.022) (-0.028828, -0.022) (-0.03, -0.023172) (-0.03, -0.024828) (-0.024828, -0.03), closed, covered)
  TopMetal1_8.sweep_along_vector((0mm, 0mm, TopMetal1_thickness))
  TopMetal1_9 [TopMetal1] = polyline(z=TopMetal1_lower_elevation, xy in mm: (-0.028828, -0.026) (-0.027172, -0.026) (-0.026, -0.024828) (-0.026, 0.024828) (-0.027172, 0.026) (-0.028828, 0.026) (-0.03, 0.024828) (-0.03, -0.024828) (-0.028828, -0.026), closed, covered)
  TopMetal1_9.sweep_along_vector((0mm, 0mm, TopMetal1_thickness))
  TopMetal1_10 [TopMetal1] = polyline(z=TopMetal1_lower_elevation, xy in mm: (-0.028828, 0.022) (-0.027172, 0.022) (-0.022, 0.027172) (-0.022, 0.028828) (-0.023172, 0.03) (-0.024828, 0.03) (-0.03, 0.024828) (-0.03, 0.023172) (-0.028828, 0.022), closed, covered)
  TopMetal1_10.sweep_along_vector((0mm, 0mm, TopMetal1_thickness))
  TopMetal1_11 [TopMetal1] = polyline(z=TopMetal1_lower_elevation, xy in mm: (-0.024828, 0.026) (-0.005172, 0.026) (-0.004, 0.027172) (-0.004, 0.028828) (-0.005172, 0.03) (-0.024828, 0.03) (-0.026, 0.028828) (-0.026, 0.027172) (-0.024828, 0.026), closed, covered)
  TopMetal1_11.sweep_along_vector((0mm, 0mm, TopMetal1_thickness))
  TopMetal1_12 [TopMetal1] = polyline(z=TopMetal1_lower_elevation, xy in mm: (-0.006828, 0.026) (-0.005172, 0.026) (-0.004, 0.027172) (-0.004, 0.048) (-0.008, 0.048) (-0.008, 0.027172) (-0.006828, 0.026), closed, covered)
  TopMetal1_12.sweep_along_vector((0mm, 0mm, TopMetal1_thickness))
  TopMetal1_13 [TopMetal1] = polyline(z=TopMetal1_lower_elevation, xy in mm: (-0.0015, -0.04) (0.0015, -0.04) (0.0015, -0.036) (-0.0015, -0.036) (-0.0015, -0.04), closed, covered)
  TopMetal1_13.sweep_along_vector((0mm, 0mm, TopMetal1_thickness))
  TopMetal1_14 [TopMetal1] = polyline(z=TopMetal1_lower_elevation, xy in mm: (0.004, 0.04) (0.008, 0.04) (0.008, 0.048) (0.004, 0.048) (0.004, 0.04), closed, covered)
  TopMetal1_14.sweep_along_vector((0mm, 0mm, TopMetal1_thickness))
  TopMetal1_15 [TopMetal1] = polyline(z=TopMetal1_lower_elevation, xy in mm: (-0.008, 0.04) (-0.004, 0.04) (-0.004, 0.048) (-0.008, 0.048) (-0.008, 0.04), closed, covered)
  TopMetal1_15.sweep_along_vector((0mm, 0mm, TopMetal1_thickness))
  pa = rectangle(corner=(-8um, -48um, 289.33um), z_size=5.65um, x_size=4um)
  pb = rectangle(corner=(4um, -48um, 289.33um), z_size=5.65um, x_size=4um)
  pc = rectangle(corner=(-8um, 48um, 289.33um), z_size=0.85um, x_size=4um)
  pd = rectangle(corner=(4um, 48um, 289.33um), z_size=0.85um, x_size=4um)
  ct = rectangle(corner=(-1.5um, -40um, 289.33um), z_size=0.85um, x_size=3um)
boundaries and excitations:
  Rad1: Radiation Faces=Air.face(all 6)
  1: Lumped Port Objects=pa Modes{Mode1{IntLine{middle of pa.edge(z at corner) -> middle of pa.edge(z opposite corner)} CharImp=Zpi RenormImp=50ohm}} Impedance=50ohm
  2: Lumped Port Objects=pb Modes{Mode1{IntLine{middle of pb.edge(z at corner) -> middle of pb.edge(z opposite corner)} CharImp=Zpi RenormImp=50ohm}} Impedance=50ohm
  3: Lumped Port Objects=pc Modes{Mode1{IntLine{middle of pc.edge(z at corner) -> middle of pc.edge(z opposite corner)} CharImp=Zpi RenormImp=50ohm}} Impedance=50ohm
  4: Lumped Port Objects=pd Modes{Mode1{IntLine{middle of pd.edge(z at corner) -> middle of pd.edge(z opposite corner)} CharImp=Zpi RenormImp=50ohm}} Impedance=50ohm
  5: Lumped Port Objects=ct Modes{Mode1{IntLine{middle of ct.edge(z at corner) -> middle of ct.edge(z opposite corner)} CharImp=Zpi RenormImp=50ohm}} Impedance=50ohm
setups:
  Setup1: HfssDriven Frequency=140000000000Hz MaxDeltaS=0.02 MaximumPasses=20 MinimumPasses=2 MinimumConvergedPasses=2 PercentRefinement=30 BasisOrder=2 Target=0.6667 PortAccuracy=2
    sweep Sweep1: 0Hz to 180000000000Hz step 10000000000Hz; Type=Interpolating InterpTolerance=0.5 InterpMaxSolns=250 MinSolvedFreq=0.01GHz InterpUsePortImped=false PassivityErrorTolerance=0.0001
source amplitudes:
  1:1: 1W 0deg
  2:1, 3:1, 4:1, 5:1: 0W 0deg
